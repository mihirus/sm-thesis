# Ansys Electronics Desktop project, version 2024.1
materials:
  vacuum: permittivity=1
  3C95: permeability=3000 core_loss_type="Power Ferrite" core_loss_cm=0.0063 core_loss_x=1.357 core_loss_y=2.851 mass_density=4800 core_loss_equiv_cut_depth=0.001meter
  Copper_temperature: thermal_modifier{Property=conductivity free_form_value="1 / (1 + 0.0039 * (Temp - 22))"} permeability=0.999991 conductivity=58000000
  Copper_temperature - Litz: thermal_modifier{Property=conductivity free_form_value="1 / (1 + 0.0039 * (Temp - 22))"} permeability=0.999991 conductivity=58000000 stacking_type="Litz Wire" wire_type=Round strand_number=2700 wire_diameter=0.0316mm litz_wire_twisting_length_factor=1

design Draft Shunt Simulation WIP (Maxwell 2D, EddyCurrent, XY geometry, model units mm)
options: ModelDepth=21.65mm
variables:
  t_shunt = (0.017*22*3.5) mm
  g_total = 0.3
geometry:
  ETD593C95 = imported_body(C:\Users\suppe\Downloads\ETD59-3C95.IGS)
  ETD593C95_1 = ETD593C95.duplicate_along_line(step=(0mm, 31mm, 0mm), total=2)
  ETD593C95_1.rotate(axis=Z, angle=180deg)
  ETD593C95_1.move(0mm, 93mm, 0mm)
  ETD593C95.unite(ETD593C95_1)
  Rectangle2 [3C95] = rectangle(corner=(-29.9mm, 62mm, 0mm), x_size=7.55mm, y_size=-53.5mm)
  Rectangle3 = rectangle(corner=(-29.9mm, 8.5mm, 0mm), x_size=59.8mm, y_size=-8.5mm)
  Rectangle4 = rectangle(corner=(22.35mm, 8.5mm, 0mm), x_size=7.55mm, y_size=53.5mm)
  Rectangle5 = rectangle(corner=(-22.35mm, 62mm, 0mm), x_size=44.7mm, y_size=-8.5mm)
  Rectangle6 = rectangle(corner=(-10.825mm, 53.5mm, 0mm), x_size=21.65mm, y_size=-45mm)
  Rectangle2.unite(Rectangle6, Rectangle5, Rectangle4, Rectangle3)
  Circle1 [Copper_temperature - Litz] = circle(normal=Z, centre=((-12.239 - 0.5) mm, 31mm, 0mm), radius=0.914mm, segments=8)
  Circle1.duplicate_along_line(step=(-2.828mm, 0mm, 0mm), total=3, attached)
  Circle1.duplicate_along_line(step=(0mm, 2.828mm, 0mm), total=2, attached)
  Circle1_Separate1..Circle1_Separate5 [Copper_temperature - Litz] = Circle1.separate_bodies()
  Circle1_Separate4.duplicate_along_line(step=(0mm, -2.828mm, 0mm), total=2, attached)
  Circle1_Separate5.duplicate_along_line(step=(0mm, -2.828mm, 0mm), total=2, attached)
  Circle1.duplicate_along_line(step=(0mm, -2.828mm, 0mm), total=2, attached)
  Circle1_Separate6 [Copper_temperature - Litz] = Circle1.separate_bodies()
  Circle1_Separate1.separate_bodies()
  Circle1_Separate2.separate_bodies()
  Circle1_Separate3.separate_bodies()
  Circle1_Separate4_Separate1 [vacuum, non-model] = Circle1_Separate4.separate_bodies()
  Circle1_Separate5_Separate1 [Copper_temperature - Litz] = Circle1_Separate5.separate_bodies()
  Rectangle7 [3C95] = rectangle(corner=((-22.35 + g_total/2) mm, (31+(2.828/2) + 2.828) mm, 0mm), x_size=(11.525-g_total) mm, y_size=t_shunt)
  Rectangle7_1 [3C95] = Rectangle7.duplicate_mirror(point=(0mm, 31mm, 0mm), normal=(0mm, -1mm, 0mm))
  Rectangle7_2 [3C95] = Rectangle7.duplicate_mirror(point=(0mm, 31mm, 0mm), normal=(1mm, 0mm, 0mm))
  Rectangle7_1_1 [3C95] = Rectangle7_1.duplicate_mirror(point=(0mm, 31mm, 0mm), normal=(1mm, 0mm, 0mm))
  Circle1_1 [Copper_temperature - Litz] = Circle1.duplicate_mirror(point=(0mm, 31mm, 0mm), normal=(1mm, 0mm, 0mm))
  Circle1_Separate1_1 [Copper_temperature - Litz] = Circle1_Separate1.duplicate_mirror(point=(0mm, 31mm, 0mm), normal=(1mm, 0mm, 0mm))
  Circle1_Separate2_1 [Copper_temperature - Litz] = Circle1_Separate2.duplicate_mirror(point=(0mm, 31mm, 0mm), normal=(1mm, 0mm, 0mm))
  Circle1_Separate3_1 [Copper_temperature - Litz] = Circle1_Separate3.duplicate_mirror(point=(0mm, 31mm, 0mm), normal=(1mm, 0mm, 0mm))
  Circle1_Separate4_1 [Copper_temperature - Litz] = Circle1_Separate4.duplicate_mirror(point=(0mm, 31mm, 0mm), normal=(1mm, 0mm, 0mm))
  Circle1_Separate5_1 [Copper_temperature - Litz] = Circle1_Separate5.duplicate_mirror(point=(0mm, 31mm, 0mm), normal=(1mm, 0mm, 0mm))
  Circle1_Separate5_Separate1_1 [Copper_temperature - Litz] = Circle1_Separate5_Separate1.duplicate_mirror(point=(0mm, 31mm, 0mm), normal=(1mm, 0mm, 0mm))
  Circle1_Separate6_1 [Copper_temperature - Litz] = Circle1_Separate6.duplicate_mirror(point=(0mm, 31mm, 0mm), normal=(1mm, 0mm, 0mm))
  Circle2 [vacuum] = circle(normal=Z, centre=((-10.825-0.82-0.5) mm, (53.5-0.82) mm, 0mm), radius=0.16mm, segments=8)
  Circle2.duplicate_along_line(step=(-0.82mm, 0mm, 0mm), total=5, attached)
  Circle2.duplicate_along_line(step=(0mm, -0.82mm, 0mm), total=20, attached)
  Circle2_Separate1 [vacuum], Circle2_Separate2 [vacuum, non-model], Circle2_Separate3..Circle2_Separate6 [vacuum], Circle2_Separate7 [vacuum, non-model], Circle2_Separate8..Circle2_Separate11 [vacuum], Circle2_Separate12 [vacuum, non-model], Circle2_Separate13..Circle2_Separate16 [vacuum], Circle2_Separate17 [vacuum, non-model], Circle2_Separate18..Circle2_Separate21 [vacuum], Circle2_Separate22 [vacuum, non-model], Circle2_Separate23..Circle2_Separate26 [vacuum], Circle2_Separate27 [vacuum, non-model], Circle2_Separate28..Circle2_Separate31 [vacuum], Circle2_Separate32 [vacuum, non-model], Circle2_Separate33..Circle2_Separate36 [vacuum], Circle2_Separate37 [vacuum, non-model], Circle2_Separate38..Circle2_Separate41 [vacuum], Circle2_Separate42 [vacuum, non-model], Circle2_Separate43..Circle2_Separate46 [vacuum], Circle2_Separate47 [vacuum, non-model], Circle2_Separate48..Circle2_Separate51 [vacuum], Circle2_Separate52 [vacuum, non-model], Circle2_Separate53..Circle2_Separate56 [vacuum], Circle2_Separate57 [vacuum, non-model], Circle2_Separate58..Circle2_Separate99 [vacuum] = Circle2.separate_bodies()
  Circle2_1 [vacuum] = Circle2.duplicate_mirror(point=(0mm, 31mm, 0mm), normal=(0mm, -1mm, 0mm))
  Circle2_Separate1_1 [vacuum] = Circle2_Separate1.duplicate_mirror(point=(0mm, 31mm, 0mm), normal=(0mm, -1mm, 0mm))
  Circle2_Separate3_1 [vacuum] = Circle2_Separate3.duplicate_mirror(point=(0mm, 31mm, 0mm), normal=(0mm, -1mm, 0mm))
  Circle2_Separate4_1 [vacuum] = Circle2_Separate4.duplicate_mirror(point=(0mm, 31mm, 0mm), normal=(0mm, -1mm, 0mm))
  Circle2_Separate5_1 [vacuum] = Circle2_Separate5.duplicate_mirror(point=(0mm, 31mm, 0mm), normal=(0mm, -1mm, 0mm))
  Circle2_Separate6_1 [vacuum] = Circle2_Separate6.duplicate_mirror(point=(0mm, 31mm, 0mm), normal=(0mm, -1mm, 0mm))
  Circle2_Separate8_1 [vacuum] = Circle2_Separate8.duplicate_mirror(point=(0mm, 31mm, 0mm), normal=(0mm, -1mm, 0mm))
  Circle2_Separate9_1 [vacuum] = Circle2_Separate9.duplicate_mirror(point=(0mm, 31mm, 0mm), normal=(0mm, -1mm, 0mm))
  Circle2_Separate10_1 [vacuum] = Circle2_Separate10.duplicate_mirror(point=(0mm, 31mm, 0mm), normal=(0mm, -1mm, 0mm))
  Circle2_Separate11_1 [vacuum] = Circle2_Separate11.duplicate_mirror(point=(0mm, 31mm, 0mm), normal=(0mm, -1mm, 0mm))
  Circle2_Separate13_1 [vacuum] = Circle2_Separate13.duplicate_mirror(point=(0mm, 31mm, 0mm), normal=(0mm, -1mm, 0mm))
  Circle2_Separate14_1 [vacuum] = Circle2_Separate14.duplicate_mirror(point=(0mm, 31mm, 0mm), normal=(0mm, -1mm, 0mm))
  Circle2_Separate15_1 [vacuum] = Circle2_Separate15.duplicate_mirror(point=(0mm, 31mm, 0mm), normal=(0mm, -1mm, 0mm))
  Circle2_Separate16_1 [vacuum] = Circle2_Separate16.duplicate_mirror(point=(0mm, 31mm, 0mm), normal=(0mm, -1mm, 0mm))
  Circle2_Separate18_1 [vacuum] = Circle2_Separate18.duplicate_mirror(point=(0mm, 31mm, 0mm), normal=(0mm, -1mm, 0mm))
  Circle2_Separate19_1 [vacuum] = Circle2_Separate19.duplicate_mirror(point=(0mm, 31mm, 0mm), normal=(0mm, -1mm, 0mm))
  Circle2_Separate20_1 [vacuum] = Circle2_Separate20.duplicate_mirror(point=(0mm, 31mm, 0mm), normal=(0mm, -1mm, 0mm))
  Circle2_Separate21_1 [vacuum] = Circle2_Separate21.duplicate_mirror(point=(0mm, 31mm, 0mm), normal=(0mm, -1mm, 0mm))
  Circle2_Separate23_1 [vacuum] = Circle2_Separate23.duplicate_mirror(point=(0mm, 31mm, 0mm), normal=(0mm, -1mm, 0mm))
  Circle2_Separate24_1 [vacuum] = Circle2_Separate24.duplicate_mirror(point=(0mm, 31mm, 0mm), normal=(0mm, -1mm, 0mm))
  Circle2_Separate25_1 [vacuum] = Circle2_Separate25.duplicate_mirror(point=(0mm, 31mm, 0mm), normal=(0mm, -1mm, 0mm))
  Circle2_Separate26_1 [vacuum] = Circle2_Separate26.duplicate_mirror(point=(0mm, 31mm, 0mm), normal=(0mm, -1mm, 0mm))
  Circle2_Separate28_1 [vacuum] = Circle2_Separate28.duplicate_mirror(point=(0mm, 31mm, 0mm), normal=(0mm, -1mm, 0mm))
  Circle2_Separate29_1 [vacuum] = Circle2_Separate29.duplicate_mirror(point=(0mm, 31mm, 0mm), normal=(0mm, -1mm, 0mm))
  Circle2_Separate30_1 [vacuum] = Circle2_Separate30.duplicate_mirror(point=(0mm, 31mm, 0mm), normal=(0mm, -1mm, 0mm))
  Circle2_Separate31_1 [vacuum] = Circle2_Separate31.duplicate_mirror(point=(0mm, 31mm, 0mm), normal=(0mm, -1mm, 0mm))
  Circle2_Separate33_1 [vacuum] = Circle2_Separate33.duplicate_mirror(point=(0mm, 31mm, 0mm), normal=(0mm, -1mm, 0mm))
  Circle2_Separate34_1 [vacuum] = Circle2_Separate34.duplicate_mirror(point=(0mm, 31mm, 0mm), normal=(0mm, -1mm, 0mm))
  Circle2_Separate35_1 [vacuum] = Circle2_Separate35.duplicate_mirror(point=(0mm, 31mm, 0mm), normal=(0mm, -1mm, 0mm))
  Circle2_Separate36_1 [vacuum] = Circle2_Separate36.duplicate_mirror(point=(0mm, 31mm, 0mm), normal=(0mm, -1mm, 0mm))
  Circle2_Separate38_1 [vacuum] = Circle2_Separate38.duplicate_mirror(point=(0mm, 31mm, 0mm), normal=(0mm, -1mm, 0mm))
  Circle2_Separate39_1 [vacuum] = Circle2_Separate39.duplicate_mirror(point=(0mm, 31mm, 0mm), normal=(0mm, -1mm, 0mm))
  Circle2_Separate40_1 [vacuum] = Circle2_Separate40.duplicate_mirror(point=(0mm, 31mm, 0mm), normal=(0mm, -1mm, 0mm))
  Circle2_Separate41_1 [vacuum] = Circle2_Separate41.duplicate_mirror(point=(0mm, 31mm, 0mm), normal=(0mm, -1mm, 0mm))
  Circle2_Separate43_1 [vacuum] = Circle2_Separate43.duplicate_mirror(point=(0mm, 31mm, 0mm), normal=(0mm, -1mm, 0mm))
  Circle2_Separate44_1 [vacuum] = Circle2_Separate44.duplicate_mirror(point=(0mm, 31mm, 0mm), normal=(0mm, -1mm, 0mm))
  Circle2_Separate45_1 [vacuum] = Circle2_Separate45.duplicate_mirror(point=(0mm, 31mm, 0mm), normal=(0mm, -1mm, 0mm))
  Circle2_Separate46_1 [vacuum] = Circle2_Separate46.duplicate_mirror(point=(0mm, 31mm, 0mm), normal=(0mm, -1mm, 0mm))
  Circle2_Separate48_1 [vacuum] = Circle2_Separate48.duplicate_mirror(point=(0mm, 31mm, 0mm), normal=(0mm, -1mm, 0mm))
  Circle2_Separate49_1 [vacuum] = Circle2_Separate49.duplicate_mirror(point=(0mm, 31mm, 0mm), normal=(0mm, -1mm, 0mm))
  Circle2_Separate50_1 [vacuum] = Circle2_Separate50.duplicate_mirror(point=(0mm, 31mm, 0mm), normal=(0mm, -1mm, 0mm))
  Circle2_Separate51_1 [vacuum] = Circle2_Separate51.duplicate_mirror(point=(0mm, 31mm, 0mm), normal=(0mm, -1mm, 0mm))
  Circle2_Separate53_1 [vacuum] = Circle2_Separate53.duplicate_mirror(point=(0mm, 31mm, 0mm), normal=(0mm, -1mm, 0mm))
  Circle2_Separate54_1 [vacuum] = Circle2_Separate54.duplicate_mirror(point=(0mm, 31mm, 0mm), normal=(0mm, -1mm, 0mm))
  Circle2_Separate55_1 [vacuum] = Circle2_Separate55.duplicate_mirror(point=(0mm, 31mm, 0mm), normal=(0mm, -1mm, 0mm))
  Circle2_Separate56_1 [vacuum] = Circle2_Separate56.duplicate_mirror(point=(0mm, 31mm, 0mm), normal=(0mm, -1mm, 0mm))
  Circle2_Separate58_1 [vacuum] = Circle2_Separate58.duplicate_mirror(point=(0mm, 31mm, 0mm), normal=(0mm, -1mm, 0mm))
  Circle2_Separate59_1 [vacuum] = Circle2_Separate59.duplicate_mirror(point=(0mm, 31mm, 0mm), normal=(0mm, -1mm, 0mm))
  Circle2_Separate60_1 [vacuum] = Circle2_Separate60.duplicate_mirror(point=(0mm, 31mm, 0mm), normal=(0mm, -1mm, 0mm))
  Circle2_Separate61_1 [vacuum] = Circle2_Separate61.duplicate_mirror(point=(0mm, 31mm, 0mm), normal=(0mm, -1mm, 0mm))
  Circle2_Separate62_1 [vacuum] = Circle2_Separate62.duplicate_mirror(point=(0mm, 31mm, 0mm), normal=(0mm, -1mm, 0mm))
  Circle2_Separate63_1 [vacuum] = Circle2_Separate63.duplicate_mirror(point=(0mm, 31mm, 0mm), normal=(0mm, -1mm, 0mm))
  Circle2_Separate64_1 [vacuum] = Circle2_Separate64.duplicate_mirror(point=(0mm, 31mm, 0mm), normal=(0mm, -1mm, 0mm))
  Circle2_Separate65_1 [vacuum] = Circle2_Separate65.duplicate_mirror(point=(0mm, 31mm, 0mm), normal=(0mm, -1mm, 0mm))
  Circle2_Separate66_1 [vacuum] = Circle2_Separate66.duplicate_mirror(point=(0mm, 31mm, 0mm), normal=(0mm, -1mm, 0mm))
  Circle2_Separate67_1 [vacuum] = Circle2_Separate67.duplicate_mirror(point=(0mm, 31mm, 0mm), normal=(0mm, -1mm, 0mm))
  Circle2_Separate68_1 [vacuum] = Circle2_Separate68.duplicate_mirror(point=(0mm, 31mm, 0mm), normal=(0mm, -1mm, 0mm))
  Circle2_Separate69_1 [vacuum] = Circle2_Separate69.duplicate_mirror(point=(0mm, 31mm, 0mm), normal=(0mm, -1mm, 0mm))
  Circle2_Separate70_1 [vacuum] = Circle2_Separate70.duplicate_mirror(point=(0mm, 31mm, 0mm), normal=(0mm, -1mm, 0mm))
  Circle2_Separate71_1 [vacuum] = Circle2_Separate71.duplicate_mirror(point=(0mm, 31mm, 0mm), normal=(0mm, -1mm, 0mm))
  Circle2_Separate72_1 [vacuum] = Circle2_Separate72.duplicate_mirror(point=(0mm, 31mm, 0mm), normal=(0mm, -1mm, 0mm))
  Circle2_Separate73_1 [vacuum] = Circle2_Separate73.duplicate_mirror(point=(0mm, 31mm, 0mm), normal=(0mm, -1mm, 0mm))
  Circle2_Separate74_1 [vacuum] = Circle2_Separate74.duplicate_mirror(point=(0mm, 31mm, 0mm), normal=(0mm, -1mm, 0mm))
  Circle2_Separate75_1 [vacuum] = Circle2_Separate75.duplicate_mirror(point=(0mm, 31mm, 0mm), normal=(0mm, -1mm, 0mm))
  Circle2_Separate76_1 [vacuum] = Circle2_Separate76.duplicate_mirror(point=(0mm, 31mm, 0mm), normal=(0mm, -1mm, 0mm))
  Circle2_Separate77_1 [vacuum] = Circle2_Separate77.duplicate_mirror(point=(0mm, 31mm, 0mm), normal=(0mm, -1mm, 0mm))
  Circle2_Separate78_1 [vacuum] = Circle2_Separate78.duplicate_mirror(point=(0mm, 31mm, 0mm), normal=(0mm, -1mm, 0mm))
  Circle2_Separate79_1 [vacuum] = Circle2_Separate79.duplicate_mirror(point=(0mm, 31mm, 0mm), normal=(0mm, -1mm, 0mm))
  Circle2_Separate80_1 [vacuum] = Circle2_Separate80.duplicate_mirror(point=(0mm, 31mm, 0mm), normal=(0mm, -1mm, 0mm))
  Circle2_Separate81_1 [vacuum] = Circle2_Separate81.duplicate_mirror(point=(0mm, 31mm, 0mm), normal=(0mm, -1mm, 0mm))
  Circle2_Separate82_1 [vacuum] = Circle2_Separate82.duplicate_mirror(point=(0mm, 31mm, 0mm), normal=(0mm, -1mm, 0mm))
  Circle2_Separate83_1 [vacuum] = Circle2_Separate83.duplicate_mirror(point=(0mm, 31mm, 0mm), normal=(0mm, -1mm, 0mm))
  Circle2_Separate84_1 [vacuum] = Circle2_Separate84.duplicate_mirror(point=(0mm, 31mm, 0mm), normal=(0mm, -1mm, 0mm))
  Circle2_Separate85_1 [vacuum] = Circle2_Separate85.duplicate_mirror(point=(0mm, 31mm, 0mm), normal=(0mm, -1mm, 0mm))
  Circle2_Separate86_1 [vacuum] = Circle2_Separate86.duplicate_mirror(point=(0mm, 31mm, 0mm), normal=(0mm, -1mm, 0mm))
  Circle2_Separate87_1 [vacuum] = Circle2_Separate87.duplicate_mirror(point=(0mm, 31mm, 0mm), normal=(0mm, -1mm, 0mm))
  Circle2_Separate88_1 [vacuum] = Circle2_Separate88.duplicate_mirror(point=(0mm, 31mm, 0mm), normal=(0mm, -1mm, 0mm))
  Circle2_Separate89_1 [vacuum] = Circle2_Separate89.duplicate_mirror(point=(0mm, 31mm, 0mm), normal=(0mm, -1mm, 0mm))
  Circle2_Separate90_1 [vacuum] = Circle2_Separate90.duplicate_mirror(point=(0mm, 31mm, 0mm), normal=(0mm, -1mm, 0mm))
  Circle2_Separate91_1 [vacuum] = Circle2_Separate91.duplicate_mirror(point=(0mm, 31mm, 0mm), normal=(0mm, -1mm, 0mm))
  Circle2_Separate92_1 [vacuum] = Circle2_Separate92.duplicate_mirror(point=(0mm, 31mm, 0mm), normal=(0mm, -1mm, 0mm))
  Circle2_Separate93_1 [vacuum] = Circle2_Separate93.duplicate_mirror(point=(0mm, 31mm, 0mm), normal=(0mm, -1mm, 0mm))
  Circle2_Separate94_1 [vacuum] = Circle2_Separate94.duplicate_mirror(point=(0mm, 31mm, 0mm), normal=(0mm, -1mm, 0mm))
  Circle2_Separate95_1 [vacuum] = Circle2_Separate95.duplicate_mirror(point=(0mm, 31mm, 0mm), normal=(0mm, -1mm, 0mm))
  Circle2_Separate96_1 [vacuum] = Circle2_Separate96.duplicate_mirror(point=(0mm, 31mm, 0mm), normal=(0mm, -1mm, 0mm))
  Circle2_Separate97_1 [vacuum] = Circle2_Separate97.duplicate_mirror(point=(0mm, 31mm, 0mm), normal=(0mm, -1mm, 0mm))
  Circle2_Separate98_1 [vacuum] = Circle2_Separate98.duplicate_mirror(point=(0mm, 31mm, 0mm), normal=(0mm, -1mm, 0mm))
  Circle2_Separate99_1 [vacuum] = Circle2_Separate99.duplicate_mirror(point=(0mm, 31mm, 0mm), normal=(0mm, -1mm, 0mm))
  Circle2_2 [vacuum] = Circle2.duplicate_mirror(point=(0mm, 31mm, 0mm), normal=(1mm, 0mm, 0mm))
  Circle2_1_1 [vacuum] = Circle2_1.duplicate_mirror(point=(0mm, 31mm, 0mm), normal=(1mm, 0mm, 0mm))
  Circle2_Separate1_2 [vacuum] = Circle2_Separate1.duplicate_mirror(point=(0mm, 31mm, 0mm), normal=(1mm, 0mm, 0mm))
  Circle2_Separate1_1_1 [vacuum] = Circle2_Separate1_1.duplicate_mirror(point=(0mm, 31mm, 0mm), normal=(1mm, 0mm, 0mm))
  Circle2_Separate3_2 [vacuum] = Circle2_Separate3.duplicate_mirror(point=(0mm, 31mm, 0mm), normal=(1mm, 0mm, 0mm))
  Circle2_Separate3_1_1 [vacuum] = Circle2_Separate3_1.duplicate_mirror(point=(0mm, 31mm, 0mm), normal=(1mm, 0mm, 0mm))
  Circle2_Separate4_2 [vacuum] = Circle2_Separate4.duplicate_mirror(point=(0mm, 31mm, 0mm), normal=(1mm, 0mm, 0mm))
  Circle2_Separate4_1_1 [vacuum] = Circle2_Separate4_1.duplicate_mirror(point=(0mm, 31mm, 0mm), normal=(1mm, 0mm, 0mm))
  Circle2_Separate5_2 [vacuum] = Circle2_Separate5.duplicate_mirror(point=(0mm, 31mm, 0mm), normal=(1mm, 0mm, 0mm))
  Circle2_Separate5_1_1 [vacuum] = Circle2_Separate5_1.duplicate_mirror(point=(0mm, 31mm, 0mm), normal=(1mm, 0mm, 0mm))
  Circle2_Separate6_2 [vacuum] = Circle2_Separate6.duplicate_mirror(point=(0mm, 31mm, 0mm), normal=(1mm, 0mm, 0mm))
  Circle2_Separate6_1_1 [vacuum] = Circle2_Separate6_1.duplicate_mirror(point=(0mm, 31mm, 0mm), normal=(1mm, 0mm, 0mm))
  Circle2_Separate8_2 [vacuum] = Circle2_Separate8.duplicate_mirror(point=(0mm, 31mm, 0mm), normal=(1mm, 0mm, 0mm))
  Circle2_Separate8_1_1 [vacuum] = Circle2_Separate8_1.duplicate_mirror(point=(0mm, 31mm, 0mm), normal=(1mm, 0mm, 0mm))
  Circle2_Separate9_2 [vacuum] = Circle2_Separate9.duplicate_mirror(point=(0mm, 31mm, 0mm), normal=(1mm, 0mm, 0mm))
  Circle2_Separate9_1_1 [vacuum] = Circle2_Separate9_1.duplicate_mirror(point=(0mm, 31mm, 0mm), normal=(1mm, 0mm, 0mm))
  Circle2_Separate10_2 [vacuum] = Circle2_Separate10.duplicate_mirror(point=(0mm, 31mm, 0mm), normal=(1mm, 0mm, 0mm))
  Circle2_Separate10_1_1 [vacuum] = Circle2_Separate10_1.duplicate_mirror(point=(0mm, 31mm, 0mm), normal=(1mm, 0mm, 0mm))
  Circle2_Separate11_2 [vacuum] = Circle2_Separate11.duplicate_mirror(point=(0mm, 31mm, 0mm), normal=(1mm, 0mm, 0mm))
  Circle2_Separate11_1_1 [vacuum] = Circle2_Separate11_1.duplicate_mirror(point=(0mm, 31mm, 0mm), normal=(1mm, 0mm, 0mm))
  Circle2_Separate13_2 [vacuum] = Circle2_Separate13.duplicate_mirror(point=(0mm, 31mm, 0mm), normal=(1mm, 0mm, 0mm))
  Circle2_Separate13_1_1 [vacuum] = Circle2_Separate13_1.duplicate_mirror(point=(0mm, 31mm, 0mm), normal=(1mm, 0mm, 0mm))
  Circle2_Separate14_2 [vacuum] = Circle2_Separate14.duplicate_mirror(point=(0mm, 31mm, 0mm), normal=(1mm, 0mm, 0mm))
  Circle2_Separate14_1_1 [vacuum] = Circle2_Separate14_1.duplicate_mirror(point=(0mm, 31mm, 0mm), normal=(1mm, 0mm, 0mm))
  Circle2_Separate15_2 [vacuum] = Circle2_Separate15.duplicate_mirror(point=(0mm, 31mm, 0mm), normal=(1mm, 0mm, 0mm))
  Circle2_Separate15_1_1 [vacuum] = Circle2_Separate15_1.duplicate_mirror(point=(0mm, 31mm, 0mm), normal=(1mm, 0mm, 0mm))
  Circle2_Separate16_2 [vacuum] = Circle2_Separate16.duplicate_mirror(point=(0mm, 31mm, 0mm), normal=(1mm, 0mm, 0mm))
  Circle2_Separate16_1_1 [vacuum] = Circle2_Separate16_1.duplicate_mirror(point=(0mm, 31mm, 0mm), normal=(1mm, 0mm, 0mm))
  Circle2_Separate18_2 [vacuum] = Circle2_Separate18.duplicate_mirror(point=(0mm, 31mm, 0mm), normal=(1mm, 0mm, 0mm))
  Circle2_Separate18_1_1 [vacuum] = Circle2_Separate18_1.duplicate_mirror(point=(0mm, 31mm, 0mm), normal=(1mm, 0mm, 0mm))
  Circle2_Separate19_2 [vacuum] = Circle2_Separate19.duplicate_mirror(point=(0mm, 31mm, 0mm), normal=(1mm, 0mm, 0mm))
  Circle2_Separate19_1_1 [vacuum] = Circle2_Separate19_1.duplicate_mirror(point=(0mm, 31mm, 0mm), normal=(1mm, 0mm, 0mm))
  Circle2_Separate20_2 [vacuum] = Circle2_Separate20.duplicate_mirror(point=(0mm, 31mm, 0mm), normal=(1mm, 0mm, 0mm))
  Circle2_Separate20_1_1 [vacuum] = Circle2_Separate20_1.duplicate_mirror(point=(0mm, 31mm, 0mm), normal=(1mm, 0mm, 0mm))
  Circle2_Separate21_2 [vacuum] = Circle2_Separate21.duplicate_mirror(point=(0mm, 31mm, 0mm), normal=(1mm, 0mm, 0mm))
  Circle2_Separate21_1_1 [vacuum] = Circle2_Separate21_1.duplicate_mirror(point=(0mm, 31mm, 0mm), normal=(1mm, 0mm, 0mm))
  Circle2_Separate23_2 [vacuum] = Circle2_Separate23.duplicate_mirror(point=(0mm, 31mm, 0mm), normal=(1mm, 0mm, 0mm))
  Circle2_Separate23_1_1 [vacuum] = Circle2_Separate23_1.duplicate_mirror(point=(0mm, 31mm, 0mm), normal=(1mm, 0mm, 0mm))
  Circle2_Separate24_2 [vacuum] = Circle2_Separate24.duplicate_mirror(point=(0mm, 31mm, 0mm), normal=(1mm, 0mm, 0mm))
  Circle2_Separate24_1_1 [vacuum] = Circle2_Separate24_1.duplicate_mirror(point=(0mm, 31mm, 0mm), normal=(1mm, 0mm, 0mm))
  Circle2_Separate25_2 [vacuum] = Circle2_Separate25.duplicate_mirror(point=(0mm, 31mm, 0mm), normal=(1mm, 0mm, 0mm))
  Circle2_Separate25_1_1 [vacuum] = Circle2_Separate25_1.duplicate_mirror(point=(0mm, 31mm, 0mm), normal=(1mm, 0mm, 0mm))
  Circle2_Separate26_2 [vacuum] = Circle2_Separate26.duplicate_mirror(point=(0mm, 31mm, 0mm), normal=(1mm, 0mm, 0mm))
  Circle2_Separate26_1_1 [vacuum] = Circle2_Separate26_1.duplicate_mirror(point=(0mm, 31mm, 0mm), normal=(1mm, 0mm, 0mm))
  Circle2_Separate28_2 [vacuum] = Circle2_Separate28.duplicate_mirror(point=(0mm, 31mm, 0mm), normal=(1mm, 0mm, 0mm))
  Circle2_Separate28_1_1 [vacuum] = Circle2_Separate28_1.duplicate_mirror(point=(0mm, 31mm, 0mm), normal=(1mm, 0mm, 0mm))
  Circle2_Separate29_2 [vacuum] = Circle2_Separate29.duplicate_mirror(point=(0mm, 31mm, 0mm), normal=(1mm, 0mm, 0mm))
  Circle2_Separate29_1_1 [vacuum] = Circle2_Separate29_1.duplicate_mirror(point=(0mm, 31mm, 0mm), normal=(1mm, 0mm, 0mm))
  Circle2_Separate30_2 [vacuum] = Circle2_Separate30.duplicate_mirror(point=(0mm, 31mm, 0mm), normal=(1mm, 0mm, 0mm))
  Circle2_Separate30_1_1 [vacuum] = Circle2_Separate30_1.duplicate_mirror(point=(0mm, 31mm, 0mm), normal=(1mm, 0mm, 0mm))
  Circle2_Separate31_2 [vacuum] = Circle2_Separate31.duplicate_mirror(point=(0mm, 31mm, 0mm), normal=(1mm, 0mm, 0mm))
  Circle2_Separate31_1_1 [vacuum] = Circle2_Separate31_1.duplicate_mirror(point=(0mm, 31mm, 0mm), normal=(1mm, 0mm, 0mm))
  Circle2_Separate33_2 [vacuum] = Circle2_Separate33.duplicate_mirror(point=(0mm, 31mm, 0mm), normal=(1mm, 0mm, 0mm))
  Circle2_Separate33_1_1 [vacuum] = Circle2_Separate33_1.duplicate_mirror(point=(0mm, 31mm, 0mm), normal=(1mm, 0mm, 0mm))
  Circle2_Separate34_2 [vacuum] = Circle2_Separate34.duplicate_mirror(point=(0mm, 31mm, 0mm), normal=(1mm, 0mm, 0mm))
  Circle2_Separate34_1_1 [vacuum] = Circle2_Separate34_1.duplicate_mirror(point=(0mm, 31mm, 0mm), normal=(1mm, 0mm, 0mm))
  Circle2_Separate35_2 [vacuum] = Circle2_Separate35.duplicate_mirror(point=(0mm, 31mm, 0mm), normal=(1mm, 0mm, 0mm))
  Circle2_Separate35_1_1 [vacuum] = Circle2_Separate35_1.duplicate_mirror(point=(0mm, 31mm, 0mm), normal=(1mm, 0mm, 0mm))
  Circle2_Separate36_2 [vacuum] = Circle2_Separate36.duplicate_mirror(point=(0mm, 31mm, 0mm), normal=(1mm, 0mm, 0mm))
  Circle2_Separate36_1_1 [vacuum] = Circle2_Separate36_1.duplicate_mirror(point=(0mm, 31mm, 0mm), normal=(1mm, 0mm, 0mm))
  Circle2_Separate38_2 [vacuum] = Circle2_Separate38.duplicate_mirror(point=(0mm, 31mm, 0mm), normal=(1mm, 0mm, 0mm))
  Circle2_Separate38_1_1 [vacuum] = Circle2_Separate38_1.duplicate_mirror(point=(0mm, 31mm, 0mm), normal=(1mm, 0mm, 0mm))
  Circle2_Separate39_2 [vacuum] = Circle2_Separate39.duplicate_mirror(point=(0mm, 31mm, 0mm), normal=(1mm, 0mm, 0mm))
  Circle2_Separate39_1_1 [vacuum] = Circle2_Separate39_1.duplicate_mirror(point=(0mm, 31mm, 0mm), normal=(1mm, 0mm, 0mm))
  Circle2_Separate40_2 [vacuum] = Circle2_Separate40.duplicate_mirror(point=(0mm, 31mm, 0mm), normal=(1mm, 0mm, 0mm))
  Circle2_Separate40_1_1 [vacuum] = Circle2_Separate40_1.duplicate_mirror(point=(0mm, 31mm, 0mm), normal=(1mm, 0mm, 0mm))
  Circle2_Separate41_2 [vacuum] = Circle2_Separate41.duplicate_mirror(point=(0mm, 31mm, 0mm), normal=(1mm, 0mm, 0mm))
  Circle2_Separate41_1_1 [vacuum] = Circle2_Separate41_1.duplicate_mirror(point=(0mm, 31mm, 0mm), normal=(1mm, 0mm, 0mm))
  Circle2_Separate43_2 [vacuum] = Circle2_Separate43.duplicate_mirror(point=(0mm, 31mm, 0mm), normal=(1mm, 0mm, 0mm))
  Circle2_Separate43_1_1 [vacuum] = Circle2_Separate43_1.duplicate_mirror(point=(0mm, 31mm, 0mm), normal=(1mm, 0mm, 0mm))
  Circle2_Separate44_2 [vacuum] = Circle2_Separate44.duplicate_mirror(point=(0mm, 31mm, 0mm), normal=(1mm, 0mm, 0mm))
  Circle2_Separate44_1_1 [vacuum] = Circle2_Separate44_1.duplicate_mirror(point=(0mm, 31mm, 0mm), normal=(1mm, 0mm, 0mm))
  Circle2_Separate45_2 [vacuum] = Circle2_Separate45.duplicate_mirror(point=(0mm, 31mm, 0mm), normal=(1mm, 0mm, 0mm))
  Circle2_Separate45_1_1 [vacuum] = Circle2_Separate45_1.duplicate_mirror(point=(0mm, 31mm, 0mm), normal=(1mm, 0mm, 0mm))
  Circle2_Separate46_2 [vacuum] = Circle2_Separate46.duplicate_mirror(point=(0mm, 31mm, 0mm), normal=(1mm, 0mm, 0mm))
  Circle2_Separate46_1_1 [vacuum] = Circle2_Separate46_1.duplicate_mirror(point=(0mm, 31mm, 0mm), normal=(1mm, 0mm, 0mm))
  Circle2_Separate48_2 [vacuum] = Circle2_Separate48.duplicate_mirror(point=(0mm, 31mm, 0mm), normal=(1mm, 0mm, 0mm))
  Circle2_Separate48_1_1 [vacuum] = Circle2_Separate48_1.duplicate_mirror(point=(0mm, 31mm, 0mm), normal=(1mm, 0mm, 0mm))
  Circle2_Separate49_2 [vacuum] = Circle2_Separate49.duplicate_mirror(point=(0mm, 31mm, 0mm), normal=(1mm, 0mm, 0mm))
  Circle2_Separate49_1_1 [vacuum] = Circle2_Separate49_1.duplicate_mirror(point=(0mm, 31mm, 0mm), normal=(1mm, 0mm, 0mm))
  Circle2_Separate50_2 [vacuum] = Circle2_Separate50.duplicate_mirror(point=(0mm, 31mm, 0mm), normal=(1mm, 0mm, 0mm))
  Circle2_Separate50_1_1 [vacuum] = Circle2_Separate50_1.duplicate_mirror(point=(0mm, 31mm, 0mm), normal=(1mm, 0mm, 0mm))
  Circle2_Separate51_2 [vacuum] = Circle2_Separate51.duplicate_mirror(point=(0mm, 31mm, 0mm), normal=(1mm, 0mm, 0mm))
  Circle2_Separate51_1_1 [vacuum] = Circle2_Separate51_1.duplicate_mirror(point=(0mm, 31mm, 0mm), normal=(1mm, 0mm, 0mm))
  Circle2_Separate53_2 [vacuum] = Circle2_Separate53.duplicate_mirror(point=(0mm, 31mm, 0mm), normal=(1mm, 0mm, 0mm))
  Circle2_Separate53_1_1 [vacuum] = Circle2_Separate53_1.duplicate_mirror(point=(0mm, 31mm, 0mm), normal=(1mm, 0mm, 0mm))
  Circle2_Separate54_2 [vacuum] = Circle2_Separate54.duplicate_mirror(point=(0mm, 31mm, 0mm), normal=(1mm, 0mm, 0mm))
  Circle2_Separate54_1_1 [vacuum] = Circle2_Separate54_1.duplicate_mirror(point=(0mm, 31mm, 0mm), normal=(1mm, 0mm, 0mm))
  Circle2_Separate55_2 [vacuum] = Circle2_Separate55.duplicate_mirror(point=(0mm, 31mm, 0mm), normal=(1mm, 0mm, 0mm))
  Circle2_Separate55_1_1 [vacuum] = Circle2_Separate55_1.duplicate_mirror(point=(0mm, 31mm, 0mm), normal=(1mm, 0mm, 0mm))
  Circle2_Separate56_2 [vacuum] = Circle2_Separate56.duplicate_mirror(point=(0mm, 31mm, 0mm), normal=(1mm, 0mm, 0mm))
  Circle2_Separate56_1_1 [vacuum] = Circle2_Separate56_1.duplicate_mirror(point=(0mm, 31mm, 0mm), normal=(1mm, 0mm, 0mm))
  Circle2_Separate58_2 [vacuum] = Circle2_Separate58.duplicate_mirror(point=(0mm, 31mm, 0mm), normal=(1mm, 0mm, 0mm))
  Circle2_Separate58_1_1 [vacuum] = Circle2_Separate58_1.duplicate_mirror(point=(0mm, 31mm, 0mm), normal=(1mm, 0mm, 0mm))
  Circle2_Separate59_2 [vacuum] = Circle2_Separate59.duplicate_mirror(point=(0mm, 31mm, 0mm), normal=(1mm, 0mm, 0mm))
  Circle2_Separate59_1_1 [vacuum] = Circle2_Separate59_1.duplicate_mirror(point=(0mm, 31mm, 0mm), normal=(1mm, 0mm, 0mm))
  Circle2_Separate60_2 [vacuum] = Circle2_Separate60.duplicate_mirror(point=(0mm, 31mm, 0mm), normal=(1mm, 0mm, 0mm))
  Circle2_Separate60_1_1 [vacuum] = Circle2_Separate60_1.duplicate_mirror(point=(0mm, 31mm, 0mm), normal=(1mm, 0mm, 0mm))
  Circle2_Separate61_2 [vacuum] = Circle2_Separate61.duplicate_mirror(point=(0mm, 31mm, 0mm), normal=(1mm, 0mm, 0mm))
  Circle2_Separate61_1_1 [vacuum] = Circle2_Separate61_1.duplicate_mirror(point=(0mm, 31mm, 0mm), normal=(1mm, 0mm, 0mm))
  Circle2_Separate62_2 [vacuum] = Circle2_Separate62.duplicate_mirror(point=(0mm, 31mm, 0mm), normal=(1mm, 0mm, 0mm))
  Circle2_Separate62_1_1 [vacuum] = Circle2_Separate62_1.duplicate_mirror(point=(0mm, 31mm, 0mm), normal=(1mm, 0mm, 0mm))
  Circle2_Separate63_2 [vacuum] = Circle2_Separate63.duplicate_mirror(point=(0mm, 31mm, 0mm), normal=(1mm, 0mm, 0mm))
  Circle2_Separate63_1_1 [vacuum] = Circle2_Separate63_1.duplicate_mirror(point=(0mm, 31mm, 0mm), normal=(1mm, 0mm, 0mm))
  Circle2_Separate64_2 [vacuum] = Circle2_Separate64.duplicate_mirror(point=(0mm, 31mm, 0mm), normal=(1mm, 0mm, 0mm))
  Circle2_Separate64_1_1 [vacuum] = Circle2_Separate64_1.duplicate_mirror(point=(0mm, 31mm, 0mm), normal=(1mm, 0mm, 0mm))
  Circle2_Separate65_2 [vacuum] = Circle2_Separate65.duplicate_mirror(point=(0mm, 31mm, 0mm), normal=(1mm, 0mm, 0mm))
  Circle2_Separate65_1_1 [vacuum] = Circle2_Separate65_1.duplicate_mirror(point=(0mm, 31mm, 0mm), normal=(1mm, 0mm, 0mm))
  Circle2_Separate66_2 [vacuum] = Circle2_Separate66.duplicate_mirror(point=(0mm, 31mm, 0mm), normal=(1mm, 0mm, 0mm))
  Circle2_Separate66_1_1 [vacuum] = Circle2_Separate66_1.duplicate_mirror(point=(0mm, 31mm, 0mm), normal=(1mm, 0mm, 0mm))
  Circle2_Separate67_2 [vacuum] = Circle2_Separate67.duplicate_mirror(point=(0mm, 31mm, 0mm), normal=(1mm, 0mm, 0mm))
  Circle2_Separate67_1_1 [vacuum] = Circle2_Separate67_1.duplicate_mirror(point=(0mm, 31mm, 0mm), normal=(1mm, 0mm, 0mm))
  Circle2_Separate68_2 [vacuum] = Circle2_Separate68.duplicate_mirror(point=(0mm, 31mm, 0mm), normal=(1mm, 0mm, 0mm))
  Circle2_Separate68_1_1 [vacuum] = Circle2_Separate68_1.duplicate_mirror(point=(0mm, 31mm, 0mm), normal=(1mm, 0mm, 0mm))
  Circle2_Separate69_2 [vacuum] = Circle2_Separate69.duplicate_mirror(point=(0mm, 31mm, 0mm), normal=(1mm, 0mm, 0mm))
  Circle2_Separate69_1_1 [vacuum] = Circle2_Separate69_1.duplicate_mirror(point=(0mm, 31mm, 0mm), normal=(1mm, 0mm, 0mm))
  Circle2_Separate70_2 [vacuum] = Circle2_Separate70.duplicate_mirror(point=(0mm, 31mm, 0mm), normal=(1mm, 0mm, 0mm))
  Circle2_Separate70_1_1 [vacuum] = Circle2_Separate70_1.duplicate_mirror(point=(0mm, 31mm, 0mm), normal=(1mm, 0mm, 0mm))
  Circle2_Separate71_2 [vacuum] = Circle2_Separate71.duplicate_mirror(point=(0mm, 31mm, 0mm), normal=(1mm, 0mm, 0mm))
  Circle2_Separate71_1_1 [vacuum] = Circle2_Separate71_1.duplicate_mirror(point=(0mm, 31mm, 0mm), normal=(1mm, 0mm, 0mm))
  Circle2_Separate72_2 [vacuum] = Circle2_Separate72.duplicate_mirror(point=(0mm, 31mm, 0mm), normal=(1mm, 0mm, 0mm))
  Circle2_Separate72_1_1 [vacuum] = Circle2_Separate72_1.duplicate_mirror(point=(0mm, 31mm, 0mm), normal=(1mm, 0mm, 0mm))
  Circle2_Separate73_2 [vacuum] = Circle2_Separate73.duplicate_mirror(point=(0mm, 31mm, 0mm), normal=(1mm, 0mm, 0mm))
  Circle2_Separate73_1_1 [vacuum] = Circle2_Separate73_1.duplicate_mirror(point=(0mm, 31mm, 0mm), normal=(1mm, 0mm, 0mm))
  Circle2_Separate74_2 [vacuum] = Circle2_Separate74.duplicate_mirror(point=(0mm, 31mm, 0mm), normal=(1mm, 0mm, 0mm))
  Circle2_Separate74_1_1 [vacuum] = Circle2_Separate74_1.duplicate_mirror(point=(0mm, 31mm, 0mm), normal=(1mm, 0mm, 0mm))
  Circle2_Separate75_2 [vacuum] = Circle2_Separate75.duplicate_mirror(point=(0mm, 31mm, 0mm), normal=(1mm, 0mm, 0mm))
  Circle2_Separate75_1_1 [vacuum] = Circle2_Separate75_1.duplicate_mirror(point=(0mm, 31mm, 0mm), normal=(1mm, 0mm, 0mm))
  Circle2_Separate76_2 [vacuum] = Circle2_Separate76.duplicate_mirror(point=(0mm, 31mm, 0mm), normal=(1mm, 0mm, 0mm))
  Circle2_Separate76_1_1 [vacuum] = Circle2_Separate76_1.duplicate_mirror(point=(0mm, 31mm, 0mm), normal=(1mm, 0mm, 0mm))
  Circle2_Separate77_2 [vacuum] = Circle2_Separate77.duplicate_mirror(point=(0mm, 31mm, 0mm), normal=(1mm, 0mm, 0mm))
  Circle2_Separate77_1_1 [vacuum] = Circle2_Separate77_1.duplicate_mirror(point=(0mm, 31mm, 0mm), normal=(1mm, 0mm, 0mm))
  Circle2_Separate78_2 [vacuum] = Circle2_Separate78.duplicate_mirror(point=(0mm, 31mm, 0mm), normal=(1mm, 0mm, 0mm))
  Circle2_Separate78_1_1 [vacuum] = Circle2_Separate78_1.duplicate_mirror(point=(0mm, 31mm, 0mm), normal=(1mm, 0mm, 0mm))
  Circle2_Separate79_2 [vacuum] = Circle2_Separate79.duplicate_mirror(point=(0mm, 31mm, 0mm), normal=(1mm, 0mm, 0mm))
  Circle2_Separate79_1_1 [vacuum] = Circle2_Separate79_1.duplicate_mirror(point=(0mm, 31mm, 0mm), normal=(1mm, 0mm, 0mm))
  Circle2_Separate80_2 [vacuum] = Circle2_Separate80.duplicate_mirror(point=(0mm, 31mm, 0mm), normal=(1mm, 0mm, 0mm))
  Circle2_Separate80_1_1 [vacuum] = Circle2_Separate80_1.duplicate_mirror(point=(0mm, 31mm, 0mm), normal=(1mm, 0mm, 0mm))
  Circle2_Separate81_2 [vacuum] = Circle2_Separate81.duplicate_mirror(point=(0mm, 31mm, 0mm), normal=(1mm, 0mm, 0mm))
  Circle2_Separate81_1_1 [vacuum] = Circle2_Separate81_1.duplicate_mirror(point=(0mm, 31mm, 0mm), normal=(1mm, 0mm, 0mm))
  Circle2_Separate82_2 [vacuum] = Circle2_Separate82.duplicate_mirror(point=(0mm, 31mm, 0mm), normal=(1mm, 0mm, 0mm))
  Circle2_Separate82_1_1 [vacuum] = Circle2_Separate82_1.duplicate_mirror(point=(0mm, 31mm, 0mm), normal=(1mm, 0mm, 0mm))
  Circle2_Separate83_2 [vacuum] = Circle2_Separate83.duplicate_mirror(point=(0mm, 31mm, 0mm), normal=(1mm, 0mm, 0mm))
  Circle2_Separate83_1_1 [vacuum] = Circle2_Separate83_1.duplicate_mirror(point=(0mm, 31mm, 0mm), normal=(1mm, 0mm, 0mm))
  Circle2_Separate84_2 [vacuum] = Circle2_Separate84.duplicate_mirror(point=(0mm, 31mm, 0mm), normal=(1mm, 0mm, 0mm))
  Circle2_Separate84_1_1 [vacuum] = Circle2_Separate84_1.duplicate_mirror(point=(0mm, 31mm, 0mm), normal=(1mm, 0mm, 0mm))
  Circle2_Separate85_2 [vacuum] = Circle2_Separate85.duplicate_mirror(point=(0mm, 31mm, 0mm), normal=(1mm, 0mm, 0mm))
  Circle2_Separate85_1_1 [vacuum] = Circle2_Separate85_1.duplicate_mirror(point=(0mm, 31mm, 0mm), normal=(1mm, 0mm, 0mm))
  Circle2_Separate86_2 [vacuum] = Circle2_Separate86.duplicate_mirror(point=(0mm, 31mm, 0mm), normal=(1mm, 0mm, 0mm))
  Circle2_Separate86_1_1 [vacuum] = Circle2_Separate86_1.duplicate_mirror(point=(0mm, 31mm, 0mm), normal=(1mm, 0mm, 0mm))
  Circle2_Separate87_2 [vacuum] = Circle2_Separate87.duplicate_mirror(point=(0mm, 31mm, 0mm), normal=(1mm, 0mm, 0mm))
  Circle2_Separate87_1_1 [vacuum] = Circle2_Separate87_1.duplicate_mirror(point=(0mm, 31mm, 0mm), normal=(1mm, 0mm, 0mm))
  Circle2_Separate88_2 [vacuum] = Circle2_Separate88.duplicate_mirror(point=(0mm, 31mm, 0mm), normal=(1mm, 0mm, 0mm))
  Circle2_Separate88_1_1 [vacuum] = Circle2_Separate88_1.duplicate_mirror(point=(0mm, 31mm, 0mm), normal=(1mm, 0mm, 0mm))
  Circle2_Separate89_2 [vacuum] = Circle2_Separate89.duplicate_mirror(point=(0mm, 31mm, 0mm), normal=(1mm, 0mm, 0mm))
  Circle2_Separate89_1_1 [vacuum] = Circle2_Separate89_1.duplicate_mirror(point=(0mm, 31mm, 0mm), normal=(1mm, 0mm, 0mm))
  Circle2_Separate90_2 [vacuum] = Circle2_Separate90.duplicate_mirror(point=(0mm, 31mm, 0mm), normal=(1mm, 0mm, 0mm))
  Circle2_Separate90_1_1 [vacuum] = Circle2_Separate90_1.duplicate_mirror(point=(0mm, 31mm, 0mm), normal=(1mm, 0mm, 0mm))
  Circle2_Separate91_2 [vacuum] = Circle2_Separate91.duplicate_mirror(point=(0mm, 31mm, 0mm), normal=(1mm, 0mm, 0mm))
  Circle2_Separate91_1_1 [vacuum] = Circle2_Separate91_1.duplicate_mirror(point=(0mm, 31mm, 0mm), normal=(1mm, 0mm, 0mm))
  Circle2_Separate92_2 [vacuum] = Circle2_Separate92.duplicate_mirror(point=(0mm, 31mm, 0mm), normal=(1mm, 0mm, 0mm))
  Circle2_Separate92_1_1 [vacuum] = Circle2_Separate92_1.duplicate_mirror(point=(0mm, 31mm, 0mm), normal=(1mm, 0mm, 0mm))
  Circle2_Separate93_2 [vacuum] = Circle2_Separate93.duplicate_mirror(point=(0mm, 31mm, 0mm), normal=(1mm, 0mm, 0mm))
  Circle2_Separate93_1_1 [vacuum] = Circle2_Separate93_1.duplicate_mirror(point=(0mm, 31mm, 0mm), normal=(1mm, 0mm, 0mm))
  Circle2_Separate94_2 [vacuum] = Circle2_Separate94.duplicate_mirror(point=(0mm, 31mm, 0mm), normal=(1mm, 0mm, 0mm))
  Circle2_Separate94_1_1 [vacuum] = Circle2_Separate94_1.duplicate_mirror(point=(0mm, 31mm, 0mm), normal=(1mm, 0mm, 0mm))
  Circle2_Separate95_2 [vacuum] = Circle2_Separate95.duplicate_mirror(point=(0mm, 31mm, 0mm), normal=(1mm, 0mm, 0mm))
  Circle2_Separate95_1_1 [vacuum] = Circle2_Separate95_1.duplicate_mirror(point=(0mm, 31mm, 0mm), normal=(1mm, 0mm, 0mm))
  Circle2_Separate96_2 [vacuum] = Circle2_Separate96.duplicate_mirror(point=(0mm, 31mm, 0mm), normal=(1mm, 0mm, 0mm))
  Circle2_Separate96_1_1 [vacuum] = Circle2_Separate96_1.duplicate_mirror(point=(0mm, 31mm, 0mm), normal=(1mm, 0mm, 0mm))
  Circle2_Separate97_2 [vacuum] = Circle2_Separate97.duplicate_mirror(point=(0mm, 31mm, 0mm), normal=(1mm, 0mm, 0mm))
  Circle2_Separate97_1_1 [vacuum] = Circle2_Separate97_1.duplicate_mirror(point=(0mm, 31mm, 0mm), normal=(1mm, 0mm, 0mm))
  Circle2_Separate98_2 [vacuum] = Circle2_Separate98.duplicate_mirror(point=(0mm, 31mm, 0mm), normal=(1mm, 0mm, 0mm))
  Circle2_Separate98_1_1 [vacuum] = Circle2_Separate98_1.duplicate_mirror(point=(0mm, 31mm, 0mm), normal=(1mm, 0mm, 0mm))
  Circle2_Separate99_2 [vacuum] = Circle2_Separate99.duplicate_mirror(point=(0mm, 31mm, 0mm), normal=(1mm, 0mm, 0mm))
  Circle2_Separate99_1_1 [vacuum] = Circle2_Separate99_1.duplicate_mirror(point=(0mm, 31mm, 0mm), normal=(1mm, 0mm, 0mm))
  group Primary = Circle1, Circle1_Separate1..Circle1_Separate6, Circle1_Separate5_Separate1, Circle1_1, Circle1_Separate1_1, Circle1_Separate2_1, Circle1_Separate3_1, Circle1_Separate4_1, Circle1_Separate5_1, Circle1_Separate5_Separate1_1, Circle1_Separate6_1
  group Secondary = Circle2, Circle2_Separate1, Circle2_Separate3..Circle2_Separate6, Circle2_Separate8..Circle2_Separate11, Circle2_Separate13..Circle2_Separate16, Circle2_Separate18..Circle2_Separate21, Circle2_Separate23..Circle2_Separate26, Circle2_Separate28..Circle2_Separate31, Circle2_Separate33..Circle2_Separate36, Circle2_Separate38..Circle2_Separate41, Circle2_Separate43..Circle2_Separate46, Circle2_Separate48..Circle2_Separate51, Circle2_Separate53..Circle2_Separate56, Circle2_Separate58..Circle2_Separate99, Circle2_1, Circle2_Separate1_1, Circle2_Separate3_1, Circle2_Separate4_1, Circle2_Separate5_1, Circle2_Separate6_1, Circle2_Separate8_1, Circle2_Separate9_1, Circle2_Separate10_1, Circle2_Separate11_1, Circle2_Separate13_1, Circle2_Separate14_1, Circle2_Separate15_1, Circle2_Separate16_1, Circle2_Separate18_1, Circle2_Separate19_1, Circle2_Separate20_1, Circle2_Separate21_1, Circle2_Separate23_1, Circle2_Separate24_1, Circle2_Separate25_1, Circle2_Separate26_1, Circle2_Separate28_1, Circle2_Separate29_1, Circle2_Separate30_1, Circle2_Separate31_1, Circle2_Separate33_1, Circle2_Separate34_1, Circle2_Separate35_1, Circle2_Separate36_1, Circle2_Separate38_1, Circle2_Separate39_1, Circle2_Separate40_1, Circle2_Separate41_1, Circle2_Separate43_1, Circle2_Separate44_1, Circle2_Separate45_1, Circle2_Separate46_1, Circle2_Separate48_1, Circle2_Separate49_1, Circle2_Separate50_1, Circle2_Separate51_1, Circle2_Separate53_1, Circle2_Separate54_1, Circle2_Separate55_1, Circle2_Separate56_1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

design Shunt Design Optimization 1 (Maxwell 2D, EddyCurrent, XY geometry, model units mm)
options: ModelDepth=21.65mm
variables:
  g_total = 0.16
  t_shunt = 6mm
geometry:
  Rectangle2 [3C95] = rectangle(corner=(-29.9mm, 62mm, 0mm), x_size=7.55mm, y_size=-53.5mm)
  Rectangle6 = rectangle(corner=(-10.825mm, 53.5mm, 0mm), x_size=21.65mm, y_size=-45mm)
  Rectangle5 = rectangle(corner=(-22.35mm, 62mm, 0mm), x_size=44.7mm, y_size=-8.5mm)
  Rectangle4 = rectangle(corner=(22.35mm, 8.5mm, 0mm), x_size=7.55mm, y_size=53.5mm)
  Rectangle3 = rectangle(corner=(-29.9mm, 8.5mm, 0mm), x_size=59.8mm, y_size=-8.5mm)
  Rectangle2.unite(Rectangle6, Rectangle5, Rectangle4, Rectangle3)
  Rectangle7 [3C95] = rectangle(corner=(-22.35+ (g_total/2) mm, (31+(1.5/2) + 0.05) mm, 0mm), x_size=(11.525-g_total) mm, y_size=t_shunt)
  Rectangle7_1 [3C95] = Rectangle7.duplicate_mirror(point=(0mm, 31mm, 0mm), normal=(0mm, -1mm, 0mm))
  Rectangle7_2 [3C95] = Rectangle7.duplicate_mirror(point=(0mm, 31mm, 0mm), normal=(1mm, 0mm, 0mm))
  Rectangle7_1_1 [3C95] = Rectangle7_1.duplicate_mirror(point=(0mm, 31mm, 0mm), normal=(1mm, 0mm, 0mm))
  Circle1 [Copper_temperature - Litz] = circle(normal=Z, centre=((-12.239+0.5) mm, 31mm, 0mm), radius=(1.5/2) mm, segments=8)
  Circle1.duplicate_along_line(step=(-1.6mm, 0mm, 0mm), total=7, attached)
  Circle2 [Copper_temperature] = circle(normal=Z, centre=((-10.825-0.82) mm, (53.5-0.82) mm, 0mm), radius=0.16mm, segments=8)
  Circle2.duplicate_along_line(step=(-1.2mm, 0mm, 0mm), total=7, attached)
  Circle2.duplicate_along_line(step=(0mm, -1.2mm, 0mm), total=12, attached)
  Circle2_1 [Copper_temperature] = Circle2.duplicate_mirror(point=(0mm, 31mm, 0mm), normal=(0mm, -1mm, 0mm))
  Circle2_2 [Copper_temperature] = Circle2.duplicate_mirror(point=(0mm, 31mm, 0mm), normal=(1mm, 0mm, 0mm))
  Circle2_1_1 [Copper_temperature] = Circle2_1.duplicate_mirror(point=(0mm, 31mm, 0mm), normal=(1mm, 0mm, 0mm))
  Circle1_1 [Copper_temperature - Litz] = Circle1.duplicate_mirror(point=(0mm, 31mm, 0mm), normal=(1mm, 0mm, 0mm))
  Region [vacuum] = region(percentage_offset: +X=50, -X=50, +Y=50, -Y=50, +Z=0, -Z=0)
  Circle1_Separate1..Circle1_Separate6 [Copper_temperature - Litz] = Circle1.separate_bodies()
  Circle1_1_Separate1..Circle1_1_Separate6 [Copper_temperature - Litz] = Circle1_1.separate_bodies()
  Circle2_Separate1, Circle2_Separate3..Circle2_Separate8, Circle2_Separate10..Circle2_Separate15, Circle2_Separate17..Circle2_Separate22, Circle2_Separate24..Circle2_Separate29, Circle2_Separate31..Circle2_Separate36, Circle2_Separate38..Circle2_Separate43, Circle2_Separate45..Circle2_Separate50, Circle2_Separate52..Circle2_Separate57, Circle2_Separate59..Circle2_Separate64, Circle2_Separate66..Circle2_Separate71, Circle2_Separate73..Circle2_Separate77, Circle2_Separate79..Circle2_Separate83 [Copper_temperature] = Circle2.separate_bodies()
  Circle2_1_Separate1, Circle2_1_Separate3..Circle2_1_Separate8, Circle2_1_Separate10..Circle2_1_Separate15, Circle2_1_Separate17..Circle2_1_Separate22, Circle2_1_Separate24..Circle2_1_Separate29, Circle2_1_Separate31..Circle2_1_Separate36, Circle2_1_Separate38..Circle2_1_Separate43, Circle2_1_Separate45..Circle2_1_Separate50, Circle2_1_Separate52..Circle2_1_Separate57, Circle2_1_Separate59..Circle2_1_Separate64, Circle2_1_Separate66..Circle2_1_Separate71, Circle2_1_Separate73..Circle2_1_Separate77, Circle2_1_Separate79..Circle2_1_Separate83 [Copper_temperature] = Circle2_1.separate_bodies()
  Circle2_2_Separate1, Circle2_2_Separate3..Circle2_2_Separate8, Circle2_2_Separate10..Circle2_2_Separate15, Circle2_2_Separate17..Circle2_2_Separate22, Circle2_2_Separate24..Circle2_2_Separate29, Circle2_2_Separate31..Circle2_2_Separate36, Circle2_2_Separate38..Circle2_2_Separate43, Circle2_2_Separate45..Circle2_2_Separate50, Circle2_2_Separate52..Circle2_2_Separate57, Circle2_2_Separate59..Circle2_2_Separate64, Circle2_2_Separate66..Circle2_2_Separate71, Circle2_2_Separate73..Circle2_2_Separate77, Circle2_2_Separate79..Circle2_2_Separate83 [Copper_temperature] = Circle2_2.separate_bodies()
  Circle2_1_1_Separate1, Circle2_1_1_Separate3..Circle2_1_1_Separate8, Circle2_1_1_Separate10..Circle2_1_1_Separate15, Circle2_1_1_Separate17..Circle2_1_1_Separate22, Circle2_1_1_Separate24..Circle2_1_1_Separate29, Circle2_1_1_Separate31..Circle2_1_1_Separate36, Circle2_1_1_Separate38..Circle2_1_1_Separate43, Circle2_1_1_Separate45..Circle2_1_1_Separate50, Circle2_1_1_Separate52..Circle2_1_1_Separate57, Circle2_1_1_Separate59..Circle2_1_1_Separate64, Circle2_1_1_Separate66..Circle2_1_1_Separate71, Circle2_1_1_Separate73..Circle2_1_1_Separate77, Circle2_1_1_Separate79..Circle2_1_1_Separate83 [Copper_temperature] = Circle2_1_1.separate_bodies()
  point Point1 = (-15mm, 35mm, 0mm)
  point Point2 = (-15mm, 34mm, 0mm)
  point Point3 = (-13mm, 35mm, 0mm)
  group Secondary_L = Circle2, Circle2_1, Circle2_Separate1, Circle2_Separate3..Circle2_Separate8, Circle2_Separate10..Circle2_Separate15, Circle2_Separate17..Circle2_Separate22, Circle2_Separate24..Circle2_Separate29, Circle2_Separate31..Circle2_Separate36, Circle2_Separate38..Circle2_Separate43, Circle2_Separate45..Circle2_Separate50, Circle2_Separate52..Circle2_Separate57, Circle2_Separate59..Circle2_Separate64, Circle2_Separate66..Circle2_Separate71, Circle2_Separate73..Circle2_Separate77, Circle2_Separate79..Circle2_Separate83, Circle2_1_Separate1, Circle2_1_Separate3..Circle2_1_Separate8, Circle2_1_Separate10..Circle2_1_Separate15, Circle2_1_Separate17..Circle2_1_Separate22, Circle2_1_Separate24..Circle2_1_Separate29, Circle2_1_Separate31..Circle2_1_Separate36, Circle2_1_Separate38..Circle2_1_Separate43, Circle2_1_Separate45..Circle2_1_Separate50, Circle2_1_Separate52..Circle2_1_Separate57, Circle2_1_Separate59..Circle2_1_Separate64, Circle2_1_Separate66..Circle2_1_Separate71, Circle2_1_Separate73..Circle2_1_Separate77, Circle2_1_Separate79..Circle2_1_Separate83
  group Primary_R = Circle1_1, Circle1_1_Separate1..Circle1_1_Separate6
  group Primary_L = Circle1, Circle1_Separate1..Circle1_Separate6
  group Secondary_R = Circle2_2, Circle2_1_1, Circle2_2_Separate1, Circle2_2_Separate3..Circle2_2_Separate8, Circle2_2_Separate10..Circle2_2_Separate15, Circle2_2_Separate17..Circle2_2_Separate22, Circle2_2_Separate24..Circle2_2_Separate29, Circle2_2_Separate31..Circle2_2_Separate36, Circle2_2_Separate38..Circle2_2_Separate43, Circle2_2_Separate45..Circle2_2_Separate50, Circle2_2_Separate52..Circle2_2_Separate57, Circle2_2_Separate59..Circle2_2_Separate64, Circle2_2_Separate66..Circle2_2_Separate71, Circle2_2_Separate73..Circle2_2_Separate77, Circle2_2_Separate79..Circle2_2_Separate83, Circle2_1_1_Separate1, Circle2_1_1_Separate3..Circle2_1_1_Separate8, Circle2_1_1_Separate10..Circle2_1_1_Separate15, Circle2_1_1_Separate17..Circle2_1_1_Separate22, Circle2_1_1_Separate24..Circle2_1_1_Separate29, Circle2_1_1_Separate31..Circle2_1_1_Separate36, Circle2_1_1_Separate38..Circle2_1_1_Separate43, Circle2_1_1_Separate45..Circle2_1_1_Separate50, Circle2_1_1_Separate52..Circle2_1_1_Separate57, Circle2_1_1_Separate59..Circle2_1_1_Separate64, Circle2_1_1_Separate66..Circle2_1_1_Separate71, Circle2_1_1_Separate73..Circle2_1_1_Separate77, Circle2_1_1_Separate79..Circle2_1_1_Separate83
boundaries and excitations:
  Balloon1: Balloon Edges=Region.edge(all 4)
  Circle1: Coil Objects=Circle1 Conductor_number=1 Winding=Primary PolarityType=Positive
  Circle1_Separate1: Coil Objects=Circle1_Separate1 Conductor_number=1 Winding=Primary PolarityType=Positive
  Circle1_Separate2: Coil Objects=Circle1_Separate2 Conductor_number=1 Winding=Primary PolarityType=Positive
  Circle1_Separate3: Coil Objects=Circle1_Separate3 Conductor_number=1 Winding=Primary PolarityType=Positive
  Circle1_Separate4: Coil Objects=Circle1_Separate4 Conductor_number=1 Winding=Primary PolarityType=Positive
  Circle1_Separate5: Coil Objects=Circle1_Separate5 Conductor_number=1 Winding=Primary PolarityType=Positive
  Circle1_Separate6: Coil Objects=Circle1_Separate6 Conductor_number=1 Winding=Primary PolarityType=Positive
  Circle1_1: Coil Objects=Circle1_1 Conductor_number=1 Winding=Primary PolarityType=Negative
  Circle1_1_Separate1: Coil Objects=Circle1_1_Separate1 Conductor_number=1 Winding=Primary PolarityType=Negative
  Circle1_1_Separate2: Coil Objects=Circle1_1_Separate2 Conductor_number=1 Winding=Primary PolarityType=Negative
  Circle1_1_Separate3: Coil Objects=Circle1_1_Separate3 Conductor_number=1 Winding=Primary PolarityType=Negative
  Circle1_1_Separate4: Coil Objects=Circle1_1_Separate4 Conductor_number=1 Winding=Primary PolarityType=Negative
  Circle1_1_Separate5: Coil Objects=Circle1_1_Separate5 Conductor_number=1 Winding=Primary PolarityType=Negative
  Circle1_1_Separate6: Coil Objects=Circle1_1_Separate6 Conductor_number=1 Winding=Primary PolarityType=Negative
  Circle2: Coil Objects=Circle2 Conductor_number=1 Winding=Secondary PolarityType=Negative
  Circle2_1: Coil Objects=Circle2_1 Conductor_number=1 Winding=Secondary PolarityType=Negative
  Circle2_Separate1: Coil Objects=Circle2_Separate1 Conductor_number=1 Winding=Secondary PolarityType=Negative
  Circle2_Separate3: Coil Objects=Circle2_Separate3 Conductor_number=1 Winding=Secondary PolarityType=Negative
  Circle2_Separate4: Coil Objects=Circle2_Separate4 Conductor_number=1 Winding=Secondary PolarityType=Negative
  Circle2_Separate5: Coil Objects=Circle2_Separate5 Conductor_number=1 Winding=Secondary PolarityType=Negative
  Circle2_Separate6: Coil Objects=Circle2_Separate6 Conductor_number=1 Winding=Secondary PolarityType=Negative
  Circle2_Separate7: Coil Objects=Circle2_Separate7 Conductor_number=1 Winding=Secondary PolarityType=Negative
  Circle2_Separate8: Coil Objects=Circle2_Separate8 Conductor_number=1 Winding=Secondary PolarityType=Negative
  Circle2_Separate10: Coil Objects=Circle2_Separate10 Conductor_number=1 Winding=Secondary PolarityType=Negative
  Circle2_Separate11: Coil Objects=Circle2_Separate11 Conductor_number=1 Winding=Secondary PolarityType=Negative
  Circle2_Separate12: Coil Objects=Circle2_Separate12 Conductor_number=1 Winding=Secondary PolarityType=Negative
  Circle2_Separate13: Coil Objects=Circle2_Separate13 Conductor_number=1 Winding=Secondary PolarityType=Negative
  Circle2_Separate14: Coil Objects=Circle2_Separate14 Conductor_number=1 Winding=Secondary PolarityType=Negative
  Circle2_Separate15: Coil Objects=Circle2_Separate15 Conductor_number=1 Winding=Secondary PolarityType=Negative
  Circle2_Separate17: Coil Objects=Circle2_Separate17 Conductor_number=1 Winding=Secondary PolarityType=Negative
  Circle2_Separate18: Coil Objects=Circle2_Separate18 Conductor_number=1 Winding=Secondary PolarityType=Negative
  Circle2_Separate19: Coil Objects=Circle2_Separate19 Conductor_number=1 Winding=Secondary PolarityType=Negative
  Circle2_Separate20: Coil Objects=Circle2_Separate20 Conductor_number=1 Winding=Secondary PolarityType=Negative
  Circle2_Separate21: Coil Objects=Circle2_Separate21 Conductor_number=1 Winding=Secondary PolarityType=Negative
  Circle2_Separate22: Coil Objects=Circle2_Separate22 Conductor_number=1 Winding=Secondary PolarityType=Negative
  Circle2_Separate24: Coil Objects=Circle2_Separate24 Conductor_number=1 Winding=Secondary PolarityType=Negative
  Circle2_Separate25: Coil Objects=Circle2_Separate25 Conductor_number=1 Winding=Secondary PolarityType=Negative
  Circle2_Separate26: Coil Objects=Circle2_Separate26 Conductor_number=1 Winding=Secondary PolarityType=Negative
  Circle2_Separate27: Coil Objects=Circle2_Separate27 Conductor_number=1 Winding=Secondary PolarityType=Negative
  Circle2_Separate28: Coil Objects=Circle2_Separate28 Conductor_number=1 Winding=Secondary PolarityType=Negative
  Circle2_Separate29: Coil Objects=Circle2_Separate29 Conductor_number=1 Winding=Secondary PolarityType=Negative
  Circle2_Separate31: Coil Objects=Circle2_Separate31 Conductor_number=1 Winding=Secondary PolarityType=Negative
  Circle2_Separate32: Coil Objects=Circle2_Separate32 Conductor_number=1 Winding=Secondary PolarityType=Negative
  Circle2_Separate33: Coil Objects=Circle2_Separate33 Conductor_number=1 Winding=Secondary PolarityType=Negative
  Circle2_Separate34: Coil Objects=Circle2_Separate34 Conductor_number=1 Winding=Secondary PolarityType=Negative
  Circle2_Separate35: Coil Objects=Circle2_Separate35 Conductor_number=1 Winding=Secondary PolarityType=Negative
  Circle2_Separate36: Coil Objects=Circle2_Separate36 Conductor_number=1 Winding=Secondary PolarityType=Negative
  Circle2_Separate38: Coil Objects=Circle2_Separate38 Conductor_number=1 Winding=Secondary PolarityType=Negative
  Circle2_Separate39: Coil Objects=Circle2_Separate39 Conductor_number=1 Winding=Secondary PolarityType=Negative
  Circle2_Separate40: Coil Objects=Circle2_Separate40 Conductor_number=1 Winding=Secondary PolarityType=Negative
  Circle2_Separate41: Coil Objects=Circle2_Separate41 Conductor_number=1 Winding=Secondary PolarityType=Negative
  Circle2_Separate42: Coil Objects=Circle2_Separate42 Conductor_number=1 Winding=Secondary PolarityType=Negative
  Circle2_Separate43: Coil Objects=Circle2_Separate43 Conductor_number=1 Winding=Secondary PolarityType=Negative
  Circle2_Separate45: Coil Objects=Circle2_Separate45 Conductor_number=1 Winding=Secondary PolarityType=Negative
  Circle2_Separate46: Coil Objects=Circle2_Separate46 Conductor_number=1 Winding=Secondary PolarityType=Negative
  Circle2_Separate47: Coil Objects=Circle2_Separate47 Conductor_number=1 Winding=Secondary PolarityType=Negative
  Circle2_Separate48: Coil Objects=Circle2_Separate48 Conductor_number=1 Winding=Secondary PolarityType=Negative
  Circle2_Separate49: Coil Objects=Circle2_Separate49 Conductor_number=1 Winding=Secondary PolarityType=Negative
  Circle2_Separate50: Coil Objects=Circle2_Separate50 Conductor_number=1 Winding=Secondary PolarityType=Negative
  Circle2_Separate52: Coil Objects=Circle2_Separate52 Conductor_number=1 Winding=Secondary PolarityType=Negative
  Circle2_Separate53: Coil Objects=Circle2_Separate53 Conductor_number=1 Winding=Secondary PolarityType=Negative
  Circle2_Separate54: Coil Objects=Circle2_Separate54 Conductor_number=1 Winding=Secondary PolarityType=Negative
  Circle2_Separate55: Coil Objects=Circle2_Separate55 Conductor_number=1 Winding=Secondary PolarityType=Negative
  Circle2_Separate56: Coil Objects=Circle2_Separate56 Conductor_number=1 Winding=Secondary PolarityType=Negative
  Circle2_Separate57: Coil Objects=Circle2_Separate57 Conductor_number=1 Winding=Secondary PolarityType=Negative
  Circle2_Separate59: Coil Objects=Circle2_Separate59 Conductor_number=1 Winding=Secondary PolarityType=Negative
  Circle2_Separate60: Coil Objects=Circle2_Separate60 Conductor_number=1 Winding=Secondary PolarityType=Negative
  Circle2_Separate61: Coil Objects=Circle2_Separate61 Conductor_number=1 Winding=Secondary PolarityType=Negative
  Circle2_Separate62: Coil Objects=Circle2_Separate62 Conductor_number=1 Winding=Secondary PolarityType=Negative
  Circle2_Separate63: Coil Objects=Circle2_Separate63 Conductor_number=1 Winding=Secondary PolarityType=Negative
  Circle2_Separate64: Coil Objects=Circle2_Separate64 Conductor_number=1 Winding=Secondary PolarityType=Negative
  Circle2_Separate66: Coil Objects=Circle2_Separate66 Conductor_number=1 Winding=Secondary PolarityType=Negative
  Circle2_Separate67: Coil Objects=Circle2_Separate67 Conductor_number=1 Winding=Secondary PolarityType=Negative
  Circle2_Separate68: Coil Objects=Circle2_Separate68 Conductor_number=1 Winding=Secondary PolarityType=Negative
  Circle2_Separate69: Coil Objects=Circle2_Separate69 Conductor_number=1 Winding=Secondary PolarityType=Negative
  Circle2_Separate70: Coil Objects=Circle2_Separate70 Conductor_number=1 Winding=Secondary PolarityType=Negative
  Circle2_Separate71: Coil Objects=Circle2_Separate71 Conductor_number=1 Winding=Secondary PolarityType=Negative
  Circle2_Separate73: Coil Objects=Circle2_Separate73 Conductor_number=1 Winding=Secondary PolarityType=Negative
  Circle2_Separate74: Coil Objects=Circle2_Separate74 Conductor_number=1 Winding=Secondary PolarityType=Negative
  Circle2_Separate75: Coil Objects=Circle2_Separate75 Conductor_number=1 Winding=Secondary PolarityType=Negative
  Circle2_Separate76: Coil Objects=Circle2_Separate76 Conductor_number=1 Winding=Secondary PolarityType=Negative
  Circle2_Separate77: Coil Objects=Circle2_Separate77 Conductor_number=1 Winding=Secondary PolarityType=Negative
  Circle2_Separate79: Coil Objects=Circle2_Separate79 Conductor_number=1 Winding=Secondary PolarityType=Negative
  Circle2_Separate80: Coil Objects=Circle2_Separate80 Conductor_number=1 Winding=Secondary PolarityType=Negative
  Circle2_Separate81: Coil Objects=Circle2_Separate81 Conductor_number=1 Winding=Secondary PolarityType=Negative
  Circle2_Separate82: Coil Objects=Circle2_Separate82 Conductor_number=1 Winding=Secondary PolarityType=Negative
  Circle2_Separate83: Coil Objects=Circle2_Separate83 Conductor_number=1 Winding=Secondary PolarityType=Negative
  Circle2_1_Separate1: Coil Objects=Circle2_1_Separate1 Conductor_number=1 Winding=Secondary PolarityType=Negative
  Circle2_1_Separate3: Coil Objects=Circle2_1_Separate3 Conductor_number=1 Winding=Secondary PolarityType=Negative
  Circle2_1_Separate4: Coil Objects=Circle2_1_Separate4 Conductor_number=1 Winding=Secondary PolarityType=Negative
  Circle2_1_Separate5: Coil Objects=Circle2_1_Separate5 Conductor_number=1 Winding=Secondary PolarityType=Negative
  Circle2_1_Separate6: Coil Objects=Circle2_1_Separate6 Conductor_number=1 Winding=Secondary PolarityType=Negative
  Circle2_1_Separate7: Coil Objects=Circle2_1_Separate7 Conductor_number=1 Winding=Secondary PolarityType=Negative
  Circle2_1_Separate8: Coil Objects=Circle2_1_Separate8 Conductor_number=1 Winding=Secondary PolarityType=Negative
  Circle2_1_Separate10: Coil Objects=Circle2_1_Separate10 Conductor_number=1 Winding=Secondary PolarityType=Negative
  Circle2_1_Separate11: Coil Objects=Circle2_1_Separate11 Conductor_number=1 Winding=Secondary PolarityType=Negative
  Circle2_1_Separate12: Coil Objects=Circle2_1_Separate12 Conductor_number=1 Winding=Secondary PolarityType=Negative
  Circle2_1_Separate13: Coil Objects=Circle2_1_Separate13 Conductor_number=1 Winding=Secondary PolarityType=Negative
  Circle2_1_Separate14: Coil Objects=Circle2_1_Separate14 Conductor_number=1 Winding=Secondary PolarityType=Negative
  Circle2_1_Separate15: Coil Objects=Circle2_1_Separate15 Conductor_number=1 Winding=Secondary PolarityType=Negative
  Circle2_1_Separate17: Coil Objects=Circle2_1_Separate17 Conductor_number=1 Winding=Secondary PolarityType=Negative
  Circle2_1_Separate18: Coil Objects=Circle2_1_Separate18 Conductor_number=1 Winding=Secondary PolarityType=Negative
  Circle2_1_Separate19: Coil Objects=Circle2_1_Separate19 Conductor_number=1 Winding=Secondary PolarityType=Negative
  Circle2_1_Separate20: Coil Objects=Circle2_1_Separate20 Conductor_number=1 Winding=Secondary PolarityType=Negative
  Circle2_1_Separate21: Coil Objects=Circle2_1_Separate21 Conductor_number=1 Winding=Secondary PolarityType=Negative
  Circle2_1_Separate22: Coil Objects=Circle2_1_Separate22 Conductor_number=1 Winding=Secondary PolarityType=Negative
  Circle2_1_Separate24: Coil Objects=Circle2_1_Separate24 Conductor_number=1 Winding=Secondary PolarityType=Negative
  Circle2_1_Separate25: Coil Objects=Circle2_1_Separate25 Conductor_number=1 Winding=Secondary PolarityType=Negative
  Circle2_1_Separate26: Coil Objects=Circle2_1_Separate26 Conductor_number=1 Winding=Secondary PolarityType=Negative
  Circle2_1_Separate27: Coil Objects=Circle2_1_Separate27 Conductor_number=1 Winding=Secondary PolarityType=Negative
  Circle2_1_Separate28: Coil Objects=Circle2_1_Separate28 Conductor_number=1 Winding=Secondary PolarityType=Negative
  Circle2_1_Separate29: Coil Objects=Circle2_1_Separate29 Conductor_number=1 Winding=Secondary PolarityType=Negative
  Circle2_1_Separate31: Coil Objects=Circle2_1_Separate31 Conductor_number=1 Winding=Secondary PolarityType=Negative
  Circle2_1_Separate32: Coil Objects=Circle2_1_Separate32 Conductor_number=1 Winding=Secondary PolarityType=Negative
  Circle2_1_Separate33: Coil Objects=Circle2_1_Separate33 Conductor_number=1 Winding=Secondary PolarityType=Negative
  Circle2_1_Separate34: Coil Objects=Circle2_1_Separate34 Conductor_number=1 Winding=Secondary PolarityType=Negative
  Circle2_1_Separate35: Coil Objects=Circle2_1_Separate35 Conductor_number=1 Winding=Secondary PolarityType=Negative
  Circle2_1_Separate36: Coil Objects=Circle2_1_Separate36 Conductor_number=1 Winding=Secondary PolarityType=Negative
  Circle2_1_Separate38: Coil Objects=Circle2_1_Separate38 Conductor_number=1 Winding=Secondary PolarityType=Negative
  Circle2_1_Separate39: Coil Objects=Circle2_1_Separate39 Conductor_number=1 Winding=Secondary PolarityType=Negative
  Circle2_1_Separate40: Coil Objects=Circle2_1_Separate40 Conductor_number=1 Winding=Secondary PolarityType=Negative
  Circle2_1_Separate41: Coil Objects=Circle2_1_Separate41 Conductor_number=1 Winding=Secondary PolarityType=Negative
  Circle2_1_Separate42: Coil Objects=Circle2_1_Separate42 Conductor_number=1 Winding=Secondary PolarityType=Negative
  Circle2_1_Separate43: Coil Objects=Circle2_1_Separate43 Conductor_number=1 Winding=Secondary PolarityType=Negative
  Circle2_1_Separate45: Coil Objects=Circle2_1_Separate45 Conductor_number=1 Winding=Secondary PolarityType=Negative
  Circle2_1_Separate46: Coil Objects=Circle2_1_Separate46 Conductor_number=1 Winding=Secondary PolarityType=Negative
  Circle2_1_Separate47: Coil Objects=Circle2_1_Separate47 Conductor_number=1 Winding=Secondary PolarityType=Negative
  Circle2_1_Separate48: Coil Objects=Circle2_1_Separate48 Conductor_number=1 Winding=Secondary PolarityType=Negative
  Circle2_1_Separate49: Coil Objects=Circle2_1_Separate49 Conductor_number=1 Winding=Secondary PolarityType=Negative
  Circle2_1_Separate50: Coil Objects=Circle2_1_Separate50 Conductor_number=1 Winding=Secondary PolarityType=Negative
  Circle2_1_Separate52: Coil Objects=Circle2_1_Separate52 Conductor_number=1 Winding=Secondary PolarityType=Negative
  Circle2_1_Separate53: Coil Objects=Circle2_1_Separate53 Conductor_number=1 Winding=Secondary PolarityType=Negative
  Circle2_1_Separate54: Coil Objects=Circle2_1_Separate54 Conductor_number=1 Winding=Secondary PolarityType=Negative
  Circle2_1_Separate55: Coil Objects=Circle2_1_Separate55 Conductor_number=1 Winding=Secondary PolarityType=Negative
  Circle2_1_Separate56: Coil Objects=Circle2_1_Separate56 Conductor_number=1 Winding=Secondary PolarityType=Negative
  Circle2_1_Separate57: Coil Objects=Circle2_1_Separate57 Conductor_number=1 Winding=Secondary PolarityType=Negative
  Circle2_1_Separate59: Coil Objects=Circle2_1_Separate59 Conductor_number=1 Winding=Secondary PolarityType=Negative
  Circle2_1_Separate60: Coil Objects=Circle2_1_Separate60 Conductor_number=1 Winding=Secondary PolarityType=Negative
  Circle2_1_Separate61: Coil Objects=Circle2_1_Separate61 Conductor_number=1 Winding=Secondary PolarityType=Negative
  Circle2_1_Separate62: Coil Objects=Circle2_1_Separate62 Conductor_number=1 Winding=Secondary PolarityType=Negative
  Circle2_1_Separate63: Coil Objects=Circle2_1_Separate63 Conductor_number=1 Winding=Secondary PolarityType=Negative
  Circle2_1_Separate64: Coil Objects=Circle2_1_Separate64 Conductor_number=1 Winding=Secondary PolarityType=Negative
  Circle2_1_Separate66: Coil Objects=Circle2_1_Separate66 Conductor_number=1 Winding=Secondary PolarityType=Negative
  Circle2_1_Separate67: Coil Objects=Circle2_1_Separate67 Conductor_number=1 Winding=Secondary PolarityType=Negative
  Circle2_1_Separate68: Coil Objects=Circle2_1_Separate68 Conductor_number=1 Winding=Secondary PolarityType=Negative
  Circle2_1_Separate69: Coil Objects=Circle2_1_Separate69 Conductor_number=1 Winding=Secondary PolarityType=Negative
  Circle2_1_Separate70: Coil Objects=Circle2_1_Separate70 Conductor_number=1 Winding=Secondary PolarityType=Negative
  Circle2_1_Separate71: Coil Objects=Circle2_1_Separate71 Conductor_number=1 Winding=Secondary PolarityType=Negative
  Circle2_1_Separate73: Coil Objects=Circle2_1_Separate73 Conductor_number=1 Winding=Secondary PolarityType=Negative
  Circle2_1_Separate74: Coil Objects=Circle2_1_Separate74 Conductor_number=1 Winding=Secondary PolarityType=Negative
  Circle2_1_Separate75: Coil Objects=Circle2_1_Separate75 Conductor_number=1 Winding=Secondary PolarityType=Negative
  Circle2_1_Separate76: Coil Objects=Circle2_1_Separate76 Conductor_number=1 Winding=Secondary PolarityType=Negative
  Circle2_1_Separate77: Coil Objects=Circle2_1_Separate77 Conductor_number=1 Winding=Secondary PolarityType=Negative
  Circle2_1_Separate79: Coil Objects=Circle2_1_Separate79 Conductor_number=1 Winding=Secondary PolarityType=Negative
  Circle2_1_Separate80: Coil Objects=Circle2_1_Separate80 Conductor_number=1 Winding=Secondary PolarityType=Negative
  Circle2_1_Separate81: Coil Objects=Circle2_1_Separate81 Conductor_number=1 Winding=Secondary PolarityType=Negative
  Circle2_1_Separate82: Coil Objects=Circle2_1_Separate82 Conductor_number=1 Winding=Secondary PolarityType=Negative
  Circle2_1_Separate83: Coil Objects=Circle2_1_Separate83 Conductor_number=1 Winding=Secondary PolarityType=Negative
  Circle2_2: Coil Objects=Circle2_2 Conductor_number=1 Winding=Secondary PolarityType=Positive
  Circle2_1_1: Coil Objects=Circle2_1_1 Conductor_number=1 Winding=Secondary PolarityType=Positive
  Circle2_2_Separate1: Coil Objects=Circle2_2_Separate1 Conductor_number=1 Winding=Secondary PolarityType=Positive
  Circle2_2_Separate3: Coil Objects=Circle2_2_Separate3 Conductor_number=1 Winding=Secondary PolarityType=Positive
  Circle2_2_Separate4: Coil Objects=Circle2_2_Separate4 Conductor_number=1 Winding=Secondary PolarityType=Positive
  Circle2_2_Separate5: Coil Objects=Circle2_2_Separate5 Conductor_number=1 Winding=Secondary PolarityType=Positive
  Circle2_2_Separate6: Coil Objects=Circle2_2_Separate6 Conductor_number=1 Winding=Secondary PolarityType=Positive
  Circle2_2_Separate7: Coil Objects=Circle2_2_Separate7 Conductor_number=1 Winding=Secondary PolarityType=Positive
  Circle2_2_Separate8: Coil Objects=Circle2_2_Separate8 Conductor_number=1 Winding=Secondary PolarityType=Positive
  Circle2_2_Separate10: Coil Objects=Circle2_2_Separate10 Conductor_number=1 Winding=Secondary PolarityType=Positive
  Circle2_2_Separate11: Coil Objects=Circle2_2_Separate11 Conductor_number=1 Winding=Secondary PolarityType=Positive
  Circle2_2_Separate12: Coil Objects=Circle2_2_Separate12 Conductor_number=1 Winding=Secondary PolarityType=Positive
  Circle2_2_Separate13: Coil Objects=Circle2_2_Separate13 Conductor_number=1 Winding=Secondary PolarityType=Positive
  Circle2_2_Separate14: Coil Objects=Circle2_2_Separate14 Conductor_number=1 Winding=Secondary PolarityType=Positive
  Circle2_2_Separate15: Coil Objects=Circle2_2_Separate15 Conductor_number=1 Winding=Secondary PolarityType=Positive
  Circle2_2_Separate17: Coil Objects=Circle2_2_Separate17 Conductor_number=1 Winding=Secondary PolarityType=Positive
  Circle2_2_Separate18: Coil Objects=Circle2_2_Separate18 Conductor_number=1 Winding=Secondary PolarityType=Positive
  Circle2_2_Separate19: Coil Objects=Circle2_2_Separate19 Conductor_number=1 Winding=Secondary PolarityType=Positive
  Circle2_2_Separate20: Coil Objects=Circle2_2_Separate20 Conductor_number=1 Winding=Secondary PolarityType=Positive
  Circle2_2_Separate21: Coil Objects=Circle2_2_Separate21 Conductor_number=1 Winding=Secondary PolarityType=Positive
  Circle2_2_Separate22: Coil Objects=Circle2_2_Separate22 Conductor_number=1 Winding=Secondary PolarityType=Positive
  Circle2_2_Separate24: Coil Objects=Circle2_2_Separate24 Conductor_number=1 Winding=Secondary PolarityType=Positive
  Circle2_2_Separate25: Coil Objects=Circle2_2_Separate25 Conductor_number=1 Winding=Secondary PolarityType=Positive
  Circle2_2_Separate26: Coil Objects=Circle2_2_Separate26 Conductor_number=1 Winding=Secondary PolarityType=Positive
  Circle2_2_Separate27: Coil Objects=Circle2_2_Separate27 Conductor_number=1 Winding=Secondary PolarityType=Positive
  Circle2_2_Separate28: Coil Objects=Circle2_2_Separate28 Conductor_number=1 Winding=Secondary PolarityType=Positive
  Circle2_2_Separate29: Coil Objects=Circle2_2_Separate29 Conductor_number=1 Winding=Secondary PolarityType=Positive
  Circle2_2_Separate31: Coil Objects=Circle2_2_Separate31 Conductor_number=1 Winding=Secondary PolarityType=Positive
  Circle2_2_Separate32: Coil Objects=Circle2_2_Separate32 Conductor_number=1 Winding=Secondary PolarityType=Positive
  Circle2_2_Separate33: Coil Objects=Circle2_2_Separate33 Conductor_number=1 Winding=Secondary PolarityType=Positive
  Circle2_2_Separate34: Coil Objects=Circle2_2_Separate34 Conductor_number=1 Winding=Secondary PolarityType=Positive
  Circle2_2_Separate35: Coil Objects=Circle2_2_Separate35 Conductor_number=1 Winding=Secondary PolarityType=Positive
  Circle2_2_Separate36: Coil Objects=Circle2_2_Separate36 Conductor_number=1 Winding=Secondary PolarityType=Positive
  Circle2_2_Separate38: Coil Objects=Circle2_2_Separate38 Conductor_number=1 Winding=Secondary PolarityType=Positive
  Circle2_2_Separate39: Coil Objects=Circle2_2_Separate39 Conductor_number=1 Winding=Secondary PolarityType=Positive
  Circle2_2_Separate40: Coil Objects=Circle2_2_Separate40 Conductor_number=1 Winding=Secondary PolarityType=Positive
  Circle2_2_Separate41: Coil Objects=Circle2_2_Separate41 Conductor_number=1 Winding=Secondary PolarityType=Positive
  Circle2_2_Separate42: Coil Objects=Circle2_2_Separate42 Conductor_number=1 Winding=Secondary PolarityType=Positive
  Circle2_2_Separate43: Coil Objects=Circle2_2_Separate43 Conductor_number=1 Winding=Secondary PolarityType=Positive
  Circle2_2_Separate45: Coil Objects=Circle2_2_Separate45 Conductor_number=1 Winding=Secondary PolarityType=Positive
  Circle2_2_Separate46: Coil Objects=Circle2_2_Separate46 Conductor_number=1 Winding=Secondary PolarityType=Positive
  Circle2_2_Separate47: Coil Objects=Circle2_2_Separate47 Conductor_number=1 Winding=Secondary PolarityType=Positive
  Circle2_2_Separate48: Coil Objects=Circle2_2_Separate48 Conductor_number=1 Winding=Secondary PolarityType=Positive
  Circle2_2_Separate49: Coil Objects=Circle2_2_Separate49 Conductor_number=1 Winding=Secondary PolarityType=Positive
  Circle2_2_Separate50: Coil Objects=Circle2_2_Separate50 Conductor_number=1 Winding=Secondary PolarityType=Positive
  Circle2_2_Separate52: Coil Objects=Circle2_2_Separate52 Conductor_number=1 Winding=Secondary PolarityType=Positive
  Circle2_2_Separate53: Coil Objects=Circle2_2_Separate53 Conductor_number=1 Winding=Secondary PolarityType=Positive
  Circle2_2_Separate54: Coil Objects=Circle2_2_Separate54 Conductor_number=1 Winding=Secondary PolarityType=Positive
  Circle2_2_Separate55: Coil Objects=Circle2_2_Separate55 Conductor_number=1 Winding=Secondary PolarityType=Positive
  Circle2_2_Separate56: Coil Objects=Circle2_2_Separate56 Conductor_number=1 Winding=Secondary PolarityType=Positive
  Circle2_2_Separate57: Coil Objects=Circle2_2_Separate57 Conductor_number=1 Winding=Secondary PolarityType=Positive
  Circle2_2_Separate59: Coil Objects=Circle2_2_Separate59 Conductor_number=1 Winding=Secondary PolarityType=Positive
  Circle2_2_Separate60: Coil Objects=Circle2_2_Separate60 Conductor_number=1 Winding=Secondary PolarityType=Positive
  Circle2_2_Separate61: Coil Objects=Circle2_2_Separate61 Conductor_number=1 Winding=Secondary PolarityType=Positive
  Circle2_2_Separate62: Coil Objects=Circle2_2_Separate62 Conductor_number=1 Winding=Secondary PolarityType=Positive
  Circle2_2_Separate63: Coil Objects=Circle2_2_Separate63 Conductor_number=1 Winding=Secondary PolarityType=Positive
  Circle2_2_Separate64: Coil Objects=Circle2_2_Separate64 Conductor_number=1 Winding=Secondary PolarityType=Positive
  Circle2_2_Separate66: Coil Objects=Circle2_2_Separate66 Conductor_number=1 Winding=Secondary PolarityType=Positive
  Circle2_2_Separate67: Coil Objects=Circle2_2_Separate67 Conductor_number=1 Winding=Secondary PolarityType=Positive
  Circle2_2_Separate68: Coil Objects=Circle2_2_Separate68 Conductor_number=1 Winding=Secondary PolarityType=Positive
  Circle2_2_Separate69: Coil Objects=Circle2_2_Separate69 Conductor_number=1 Winding=Secondary PolarityType=Positive
  Circle2_2_Separate70: Coil Objects=Circle2_2_Separate70 Conductor_number=1 Winding=Secondary PolarityType=Positive
  Circle2_2_Separate71: Coil Objects=Circle2_2_Separate71 Conductor_number=1 Winding=Secondary PolarityType=Positive
  Circle2_2_Separate73: Coil Objects=Circle2_2_Separate73 Conductor_number=1 Winding=Secondary PolarityType=Positive
  Circle2_2_Separate74: Coil Objects=Circle2_2_Separate74 Conductor_number=1 Winding=Secondary PolarityType=Positive
  Circle2_2_Separate75: Coil Objects=Circle2_2_Separate75 Conductor_number=1 Winding=Secondary PolarityType=Positive
  Circle2_2_Separate76: Coil Objects=Circle2_2_Separate76 Conductor_number=1 Winding=Secondary PolarityType=Positive
  Circle2_2_Separate77: Coil Objects=Circle2_2_Separate77 Conductor_number=1 Winding=Secondary PolarityType=Positive
  Circle2_2_Separate79: Coil Objects=Circle2_2_Separate79 Conductor_number=1 Winding=Secondary PolarityType=Positive
  Circle2_2_Separate80: Coil Objects=Circle2_2_Separate80 Conductor_number=1 Winding=Secondary PolarityType=Positive
  Circle2_2_Separate81: Coil Objects=Circle2_2_Separate81 Conductor_number=1 Winding=Secondary PolarityType=Positive
  Circle2_2_Separate82: Coil Objects=Circle2_2_Separate82 Conductor_number=1 Winding=Secondary PolarityType=Positive
  Circle2_2_Separate83: Coil Objects=Circle2_2_Separate83 Conductor_number=1 Winding=Secondary PolarityType=Positive
  Circle2_1_1_Separate1: Coil Objects=Circle2_1_1_Separate1 Conductor_number=1 Winding=Secondary PolarityType=Positive
  Circle2_1_1_Separate3: Coil Objects=Circle2_1_1_Separate3 Conductor_number=1 Winding=Secondary PolarityType=Positive
  Circle2_1_1_Separate4: Coil Objects=Circle2_1_1_Separate4 Conductor_number=1 Winding=Secondary PolarityType=Positive
  Circle2_1_1_Separate5: Coil Objects=Circle2_1_1_Separate5 Conductor_number=1 Winding=Secondary PolarityType=Positive
  Circle2_1_1_Separate6: Coil Objects=Circle2_1_1_Separate6 Conductor_number=1 Winding=Secondary PolarityType=Positive
  Circle2_1_1_Separate7: Coil Objects=Circle2_1_1_Separate7 Conductor_number=1 Winding=Secondary PolarityType=Positive
  Circle2_1_1_Separate8: Coil Objects=Circle2_1_1_Separate8 Conductor_number=1 Winding=Secondary PolarityType=Positive
  Circle2_1_1_Separate10: Coil Objects=Circle2_1_1_Separate10 Conductor_number=1 Winding=Secondary PolarityType=Positive
  Circle2_1_1_Separate11: Coil Objects=Circle2_1_1_Separate11 Conductor_number=1 Winding=Secondary PolarityType=Positive
  Circle2_1_1_Separate12: Coil Objects=Circle2_1_1_Separate12 Conductor_number=1 Winding=Secondary PolarityType=Positive
  Circle2_1_1_Separate13: Coil Objects=Circle2_1_1_Separate13 Conductor_number=1 Winding=Secondary PolarityType=Positive
  Circle2_1_1_Separate14: Coil Objects=Circle2_1_1_Separate14 Conductor_number=1 Winding=Secondary PolarityType=Positive
  Circle2_1_1_Separate15: Coil Objects=Circle2_1_1_Separate15 Conductor_number=1 Winding=Secondary PolarityType=Positive
  Circle2_1_1_Separate17: Coil Objects=Circle2_1_1_Separate17 Conductor_number=1 Winding=Secondary PolarityType=Positive
  Circle2_1_1_Separate18: Coil Objects=Circle2_1_1_Separate18 Conductor_number=1 Winding=Secondary PolarityType=Positive
  Circle2_1_1_Separate19: Coil Objects=Circle2_1_1_Separate19 Conductor_number=1 Winding=Secondary PolarityType=Positive
  Circle2_1_1_Separate20: Coil Objects=Circle2_1_1_Separate20 Conductor_number=1 Winding=Secondary PolarityType=Positive
  Circle2_1_1_Separate21: Coil Objects=Circle2_1_1_Separate21 Conductor_number=1 Winding=Secondary PolarityType=Positive
  Circle2_1_1_Separate22: Coil Objects=Circle2_1_1_Separate22 Conductor_number=1 Winding=Secondary PolarityType=Positive
  Circle2_1_1_Separate24: Coil Objects=Circle2_1_1_Separate24 Conductor_number=1 Winding=Secondary PolarityType=Positive
  Circle2_1_1_Separate25: Coil Objects=Circle2_1_1_Separate25 Conductor_number=1 Winding=Secondary PolarityType=Positive
  Circle2_1_1_Separate26: Coil Objects=Circle2_1_1_Separate26 Conductor_number=1 Winding=Secondary PolarityType=Positive
  Circle2_1_1_Separate27: Coil Objects=Circle2_1_1_Separate27 Conductor_number=1 Winding=Secondary PolarityType=Positive
  Circle2_1_1_Separate28: Coil Objects=Circle2_1_1_Separate28 Conductor_number=1 Winding=Secondary PolarityType=Positive
  Circle2_1_1_Separate29: Coil Objects=Circle2_1_1_Separate29 Conductor_number=1 Winding=Secondary PolarityType=Positive
  Circle2_1_1_Separate31: Coil Objects=Circle2_1_1_Separate31 Conductor_number=1 Winding=Secondary PolarityType=Positive
  Circle2_1_1_Separate32: Coil Objects=Circle2_1_1_Separate32 Conductor_number=1 Winding=Secondary PolarityType=Positive
  Circle2_1_1_Separate33: Coil Objects=Circle2_1_1_Separate33 Conductor_number=1 Winding=Secondary PolarityType=Positive
  Circle2_1_1_Separate34: Coil Objects=Circle2_1_1_Separate34 Conductor_number=1 Winding=Secondary PolarityType=Positive
  Circle2_1_1_Separate35: Coil Objects=Circle2_1_1_Separate35 Conductor_number=1 Winding=Secondary PolarityType=Positive
  Circle2_1_1_Separate36: Coil Objects=Circle2_1_1_Separate36 Conductor_number=1 Winding=Secondary PolarityType=Positive
  Circle2_1_1_Separate38: Coil Objects=Circle2_1_1_Separate38 Conductor_number=1 Winding=Secondary PolarityType=Positive
  Circle2_1_1_Separate39: Coil Objects=Circle2_1_1_Separate39 Conductor_number=1 Winding=Secondary PolarityType=Positive
  Circle2_1_1_Separate40: Coil Objects=Circle2_1_1_Separate40 Conductor_number=1 Winding=Secondary PolarityType=Positive
  Circle2_1_1_Separate41: Coil Objects=Circle2_1_1_Separate41 Conductor_number=1 Winding=Secondary PolarityType=Positive
  Circle2_1_1_Separate42: Coil Objects=Circle2_1_1_Separate42 Conductor_number=1 Winding=Secondary PolarityType=Positive
  Circle2_1_1_Separate43: Coil Objects=Circle2_1_1_Separate43 Conductor_number=1 Winding=Secondary PolarityType=Positive
  Circle2_1_1_Separate45: Coil Objects=Circle2_1_1_Separate45 Conductor_number=1 Winding=Secondary PolarityType=Positive
  Circle2_1_1_Separate46: Coil Objects=Circle2_1_1_Separate46 Conductor_number=1 Winding=Secondary PolarityType=Positive
  Circle2_1_1_Separate47: Coil Objects=Circle2_1_1_Separate47 Conductor_number=1 Winding=Secondary PolarityType=Positive
  Circle2_1_1_Separate48: Coil Objects=Circle2_1_1_Separate48 Conductor_number=1 Winding=Secondary PolarityType=Positive
  Circle2_1_1_Separate49: Coil Objects=Circle2_1_1_Separate49 Conductor_number=1 Winding=Secondary PolarityType=Positive
  Circle2_1_1_Separate50: Coil Objects=Circle2_1_1_Separate50 Conductor_number=1 Winding=Secondary PolarityType=Positive
  Circle2_1_1_Separate52: Coil Objects=Circle2_1_1_Separate52 Conductor_number=1 Winding=Secondary PolarityType=Positive
  Circle2_1_1_Separate53: Coil Objects=Circle2_1_1_Separate53 Conductor_number=1 Winding=Secondary PolarityType=Positive
  Circle2_1_1_Separate54: Coil Objects=Circle2_1_1_Separate54 Conductor_number=1 Winding=Secondary PolarityType=Positive
  Circle2_1_1_Separate55: Coil Objects=Circle2_1_1_Separate55 Conductor_number=1 Winding=Secondary PolarityType=Positive
  Circle2_1_1_Separate56: Coil Objects=Circle2_1_1_Separate56 Conductor_number=1 Winding=Secondary PolarityType=Positive
  Circle2_1_1_Separate57: Coil Objects=Circle2_1_1_Separate57 Conductor_number=1 Winding=Secondary PolarityType=Positive
  Circle2_1_1_Separate59: Coil Objects=Circle2_1_1_Separate59 Conductor_number=1 Winding=Secondary PolarityType=Positive
  Circle2_1_1_Separate60: Coil Objects=Circle2_1_1_Separate60 Conductor_number=1 Winding=Secondary PolarityType=Positive
  Circle2_1_1_Separate61: Coil Objects=Circle2_1_1_Separate61 Conductor_number=1 Winding=Secondary PolarityType=Positive
  Circle2_1_1_Separate62: Coil Objects=Circle2_1_1_Separate62 Conductor_number=1 Winding=Secondary PolarityType=Positive
  Circle2_1_1_Separate63: Coil Objects=Circle2_1_1_Separate63 Conductor_number=1 Winding=Secondary PolarityType=Positive
  Circle2_1_1_Separate64: Coil Objects=Circle2_1_1_Separate64 Conductor_number=1 Winding=Secondary PolarityType=Positive
  Circle2_1_1_Separate66: Coil Objects=Circle2_1_1_Separate66 Conductor_number=1 Winding=Secondary PolarityType=Positive
  Circle2_1_1_Separate67: Coil Objects=Circle2_1_1_Separate67 Conductor_number=1 Winding=Secondary PolarityType=Positive
  Circle2_1_1_Separate68: Coil Objects=Circle2_1_1_Separate68 Conductor_number=1 Winding=Secondary PolarityType=Positive
  Circle2_1_1_Separate69: Coil Objects=Circle2_1_1_Separate69 Conductor_number=1 Winding=Secondary PolarityType=Positive
  Circle2_1_1_Separate70: Coil Objects=Circle2_1_1_Separate70 Conductor_number=1 Winding=Secondary PolarityType=Positive
  Circle2_1_1_Separate71: Coil Objects=Circle2_1_1_Separate71 Conductor_number=1 Winding=Secondary PolarityType=Positive
  Circle2_1_1_Separate73: Coil Objects=Circle2_1_1_Separate73 Conductor_number=1 Winding=Secondary PolarityType=Positive
  Circle2_1_1_Separate74: Coil Objects=Circle2_1_1_Separate74 Conductor_number=1 Winding=Secondary PolarityType=Positive
  Circle2_1_1_Separate75: Coil Objects=Circle2_1_1_Separate75 Conductor_number=1 Winding=Secondary PolarityType=Positive
  Circle2_1_1_Separate76: Coil Objects=Circle2_1_1_Separate76 Conductor_number=1 Winding=Secondary PolarityType=Positive
  Circle2_1_1_Separate77: Coil Objects=Circle2_1_1_Separate77 Conductor_number=1 Winding=Secondary PolarityType=Positive
  Circle2_1_1_Separate79: Coil Objects=Circle2_1_1_Separate79 Conductor_number=1 Winding=Secondary PolarityType=Positive
  Circle2_1_1_Separate80: Coil Objects=Circle2_1_1_Separate80 Conductor_number=1 Winding=Secondary PolarityType=Positive
  Circle2_1_1_Separate81: Coil Objects=Circle2_1_1_Separate81 Conductor_number=1 Winding=Secondary PolarityType=Positive
  Circle2_1_1_Separate82: Coil Objects=Circle2_1_1_Separate82 Conductor_number=1 Winding=Secondary PolarityType=Positive
  Circle2_1_1_Separate83: Coil Objects=Circle2_1_1_Separate83 Conductor_number=1 Winding=Secondary PolarityType=Positive
  Primary: Winding Group Type=Current IsSolid=false Current=7.1A ParallelBranchesNum=1 Phase=0deg
  Secondary: Winding Group Type=Voltage IsSolid=true Current=0mA Resistance=20000ohm Inductance=0nH Voltage=0mV ParallelBranchesNum=1 Phase=0deg
parameters:
  Matrix1: Matrix Primary, Secondary:
setups:
  Setup1: EddyCurrent MaximumPasses=10 MinimumPasses=2 MinimumConvergedPasses=1 PercentRefinement=30 PercentError=1 NonLinearResidual=0.0001 Frequency=200000Hz
field plots:
  Mag_B1: B over Rectangle2, Rectangle7, Rectangle7_1, Rectangle7_1_1, Rectangle7_2 on Setup1 : LastAdaptive at Freq=200000Hz Phase=0deg
  emloss1: EM-Loss over Circle1, Circle2, Circle2_1, Circle2_2, Circle2_1_1, Circle1_1, Circle1_Separate1..Circle1_Separate6, Circle1_1_Separate1..Circle1_1_Separate6, Circle2_Separate1, Circle2_Separate3..Circle2_Separate8, Circle2_Separate10..Circle2_Separate15, Circle2_Separate17..Circle2_Separate22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 on Setup1 : LastAdaptive at Freq=200000Hz Phase=0deg
  JAtPhase1: J over Circle1, Circle2, Circle2_1, Circle2_2, Circle2_1_1, Circle1_1, Circle1_Separate1..Circle1_Separate6, Circle1_1_Separate1..Circle1_1_Separate6, Circle2_Separate1, Circle2_Separate3..Circle2_Separate8, Circle2_Separate10..Circle2_Separate15, Circle2_Separate17..Circle2_Separate22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 on Setup1 : LastAdaptive at Freq=200000Hz Phase=0deg
  Flux_Lines1: A over Rectangle2, Rectangle7, Rectangle7_1, Rectangle7_1_1, Rectangle7_2 on Setup1 : LastAdaptive at Freq=200000Hz Phase=0deg
reports:
  L Table 1: L(Primary,Primary)*(1-CplCoef(Primary,Primary)^2) vs Freq on Setup1 : LastAdaptive
  L Table 2: L(Primary,Primary)*(1-CplCoef(Primary,Secondary)^2) vs Freq on Setup1 : LastAdaptive
