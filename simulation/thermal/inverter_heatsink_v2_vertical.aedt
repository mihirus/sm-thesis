# Ansys Electronics Desktop project, version 2023.2
materials:
  Al-Extruded: thermal_conductivity=205 mass_density=2800 specific_heat=900 youngs_modulus=69000000000 poissons_ratio=0.33 thermal_expansion_coefficient=2.277e-06 thermal_material_type=Solid
  air: permittivity=1.0006 permeability=1.0000004 thermal_conductivity=0.0261 mass_density=1.1614 specific_heat=1005 thermal_expansion_coefficient=0.00333 thermal_material_type=Fluid diffusivity=2.88e-05 molecular_mass=0.028966 viscosity=1.84e-05 material_refractive_index=1.000293
  Aluminum 6061-T4: thermal_conductivity=154 mass_density=2700 specific_heat=896 thermal_material_type=Solid
surface materials:
  Steel-oxidised-surface: surface_emissivity=0.8

design IcepakDesign1 (Icepak, SteadyState TemperatureAndFlow, model units mm)
options: Default_Fluid_Material=air Default_Solid_Material=Al-Extruded Default_Surface_Material=Steel-oxidised-surface AmbientTemperature=20cel AmbientPressure=0n_per_meter_sq AmbientRadiationTemperature=20cel Gravity_Vector_CS_ID=Global Gravity_Vector_Axis=Z Positive=false Altitude=0meter
geometry:
  Region [air] = region(absolute_offset: +X=100mm, -X=100mm, +Y=100mm, -Y=100mm, +Z=100mm, -Z=1mm)
  Box1 [Al-Extruded] = box(corner=(4.4137931mm, 7.9374917mm, -10.581029mm), size=(15.999992mm, -7.9374917mm, -0.1mm))
  inverter_sink_v2_vertical [Aluminum 6061-T4] = imported_body(C:\Users\mihir\Documents\research\cad\inverter_heat_sinks\inverter_sink_v2_vertical.IGS)
  inverter_sink_v2_vertical.rotate(axis=Y, angle=270deg)
boundaries and excitations:
  StationaryWall1: Stationary Wall Faces=Region.face(all 6) Thickness=0mm Solid_Material=Al-Extruded External_Condition=Temperature Heat_Flux=0irrad_W_per_m2 Temperature=AmbientTemp Heat_Transfer_Coefficient=0w_per_m2kel Reference_Temperature=AmbientTemp Heat_Transfer_Data{Heat_Transfer_Convection_Type="Forced Convection"} External_Material=Steel-oxidised-surface External_Radiation_Reference_Temperature=AmbientTemp External_Radiation_View_Factor=1
  Source1: Source Objects=Box1 Thermal_Condition="Total Power" Total_Power=5W
  StationaryWall2: Stationary Wall Faces=Box1.face(-z) Thickness=0mm Solid_Material=Al-Extruded External_Condition="Heat Flux" Heat_Flux=0irrad_W_per_m2 Temperature=AmbientTemp Heat_Transfer_Coefficient=0w_per_m2kel Reference_Temperature=AmbientTemp Heat_Transfer_Data{Heat_Transfer_Convection_Type="Forced Convection"} External_Material=Steel-oxidised-surface External_Radiation_Reference_Temperature=AmbientTemp External_Radiation_View_Factor=1
mesh:
  MeshRegions:  Global{MeshMethod=MesherHD ComputeGap MeshRegionResolution=3 MinGapX=1mm MinGapY=1mm MinGapZ=1mm Objects=Region FacetLevel=3 ProximitySizeFunction CurvatureSizeFunction OptimizePCBMesh}
  MeshOperations:
setups:
  Setup1: IcepakSteadyState Flow_Regime=Laminar Include_Temperature=true Include_Flow=true Include_Gravity Solution_Initialization_-_Z_Velocity=0.000980665m_per_sec Convergence_Criteria_-_Flow=0.001 Convergence_Criteria_-_Energy=1e-07 Convergence_Criteria_-_Discrete_Ordinates=1e-06 Radiation_Model="Discrete Ordinates Model" Flow_Iteration_Per_Radiation_Iteration=10 Time_Step_Interval=1 ThetaDivision=2 PhiDivision=2 ThetaPixels=2 PhiPixels=2 Under-relaxation_-_Pressure=0.7 Under-relaxation_-_Momentum=0.3 Under-relaxation_-_Temperature=1 Discretization_Scheme_-_Pressure=Standard Discretization_Scheme_-_Momentum=First Discretization_Scheme_-_Temperature=First Discretization_Scheme_-_Discrete_Ordinates=First Convergence_Criteria_-_Max_Iterations=100
field plots:
  SurfTemperature1: Temperature over inverter_sink_v2_vertical.face(at (12.4138, 0, 10.419)) Box1.face(-z) on Setup1 : SteadyState
