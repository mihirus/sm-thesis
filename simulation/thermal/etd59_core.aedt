# Ansys Electronics Desktop project, version 2023.2
materials:
  Al-Extruded: thermal_conductivity=205 mass_density=2800 specific_heat=900 youngs_modulus=69000000000 poissons_ratio=0.33 thermal_expansion_coefficient=2.277e-06 thermal_material_type=Solid
  air: permittivity=1.0006 permeability=1.0000004 thermal_conductivity=0.0261 mass_density=1.1614 specific_heat=1005 thermal_expansion_coefficient=0.00333 thermal_material_type=Fluid diffusivity=2.88e-05 molecular_mass=0.028966 viscosity=1.84e-05 material_refractive_index=1.000293
  ferrite: permittivity=12 permeability=1000 conductivity=0.01 thermal_conductivity=4 mass_density=4600 specific_heat=750 youngs_modulus=119000000000 thermal_expansion_coefficient=1e-05
surface materials:
  Steel-oxidised-surface: surface_emissivity=0.8

design IcepakDesign1 (Icepak, SteadyState TemperatureAndFlow, model units mm)
options: Default_Fluid_Material=air Default_Solid_Material=Al-Extruded Default_Surface_Material=Steel-oxidised-surface AmbientTemperature=20cel AmbientPressure=0n_per_meter_sq AmbientRadiationTemperature=20cel Gravity_Vector_CS_ID=Global Gravity_Vector_Axis=Z Positive=false Altitude=0meter
geometry:
  etd59_core [ferrite] = imported_body(C:\Users\mihir\Documents\Converter Designs\igs\etd59_core.IGS)
  Region [air] = region(percentage_offset=50 on all sides)
boundaries and excitations:
  Source1: Source Objects=etd59_core Thermal_Condition="Total Power" Total_Power=8W
  StationaryWall1: Stationary Wall Faces=Region.face(all 6) Thickness=0mm Solid_Material=Al-Extruded External_Condition=Temperature Heat_Flux=0irrad_W_per_m2 Temperature=AmbientTemp Heat_Transfer_Coefficient=0w_per_m2kel Reference_Temperature=AmbientTemp Heat_Transfer_Data{Heat_Transfer_Convection_Type="Forced Convection"} External_Material=Steel-oxidised-surface External_Radiation_Reference_Temperature=AmbientTemp External_Radiation_View_Factor=1
  StationaryWall2: Stationary Wall Faces=etd59_core.face(at (11.05, 31.2, 2.26639e-09), at (-11.05, 31.2, -2.26639e-09), at (-10.9, 53.2, 0), at (10.9, 53.2, 0), at (-10.9, 9.2, 0), at (10.9, 9.2, 0), at (21.8, 31.2, 1.14879e-09), at (-21.8, 31.2, 0), at (0, 31.2, -11.05), at (0, 31.2, 11.05)) Thickness=0mm Solid_Material=Al-Extruded External_Condition="Heat Flux" Heat_Flux=0irrad_W_per_m2 Temperature=AmbientTemp Heat_Transfer_Coefficient=0w_per_m2kel Reference_Temperature=AmbientTemp Heat_Transfer_Data{Heat_Transfer_Convection_Type="Forced Convection"} External_Material=Steel-oxidised-surface External_Radiation_Reference_Temperature=AmbientTemp External_Radiation_View_Factor=1
mesh:
  MeshRegions:  Global{MeshMethod=MesherHD ComputeGap MeshRegionResolution=3 MinGapX=1mm MinGapY=1mm MinGapZ=1mm Objects=Region FacetLevel=3 ProximitySizeFunction CurvatureSizeFunction OptimizePCBMesh}
  MeshOperations:
setups:
  Setup1: IcepakSteadyState Flow_Regime=Laminar Include_Temperature=true Include_Flow=true Include_Gravity Solution_Initialization_-_Z_Velocity=0.000980665m_per_sec Convergence_Criteria_-_Flow=0.001 Convergence_Criteria_-_Energy=1e-12 Convergence_Criteria_-_Discrete_Ordinates=1e-06 Radiation_Model="Discrete Ordinates Model" Flow_Iteration_Per_Radiation_Iteration=10 Time_Step_Interval=1 ThetaDivision=2 PhiDivision=2 ThetaPixels=2 PhiPixels=2 Under-relaxation_-_Pressure=0.7 Under-relaxation_-_Momentum=0.3 Under-relaxation_-_Temperature=1 Discretization_Scheme_-_Pressure=Standard Discretization_Scheme_-_Momentum=First Discretization_Scheme_-_Temperature=First Discretization_Scheme_-_Discrete_Ordinates=First Convergence_Criteria_-_Max_Iterations=100
field plots:
  SurfTemperature1: Temperature over etd59_core.face(at (0, 31.2, -11.05), at (0, 31.2, 11.05), at (29.9, 31.2, 0), at (0, 62.4, 0), at (-29.9, 31.2, 0), at (0, 0, 0)) on Setup1 : SteadyState
